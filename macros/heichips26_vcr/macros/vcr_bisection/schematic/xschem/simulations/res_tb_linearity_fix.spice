** sch_path: /home/santi/heichips26-voltage-controlled-resistor/macros/voltage_controlled_resistors/macros/vcr_bisection/testbenches/xschem/res_tb_linearity_fix.sch
**.subckt res_tb_linearity_fix
VDD VDD GND {VDD}
VS vsweep GND 1.5
Vmeas vd net1 0
.save i(vmeas)
vc vc_p GND 0
x1 vc_p net1 vb VDD GND vcr_bisection
VT2 vb GND 0.01
Vdummy vd vsweep 0
**** begin user architecture code

.lib cornerMOSlv.lib mos_tt
.lib cornerMOShv.lib mos_tt
.lib cornerRES.lib res_typ
.lib cornerDIO.lib dio_tt
.lib cornerCAP.lib cap_typ

* .include ../../../netlist/pex/inverter_magic_pex_3.spice
.param VDD=3.3
.csparam VDD=VDD
.param Vcm=2.3
.csparam Vcm=Vcm
.param temp=27
.options savecurrents klu method=gear reltol=1e-3 abstol=1e-15 gmin=1e-15 rshunt=1e13
.control
let vcc = 1.5

save all
set appendwrite

repeat 5
  alter vc $&vcc

  * DC Sweep
  dc VS 0.01 3 1m
  remzerovec
  let vcc = vcc + 0.3
end
write res_tb_linearity_fix.raw
set appendwrite

* Plotting
plot (dc1.v(vd) - dc1.v(vb))/(dc1.i(vmeas)) (dc2.v(vd) - dc2.v(vb))/(dc2.i(vmeas)) (dc3.v(vd) - dc3.v(vb))/(dc3.i(vmeas)) (dc4.v(vd) - dc4.v(vb))/(dc4.i(vmeas)) (dc5.v(vd) - dc5.v(vb))/(dc5.i(vmeas)) ylimit 0 10k

plot dc1.i(vmeas) dc2.i(vmeas) dc3.i(vmeas) dc4.i(vmeas) dc5.i(vmeas)

* Write Data
unset appendwrite
set wr_vecnames
set wr_singlescale
wrdata ../plot_simulations/data/res_tb_linearity_fix.txt v(vc_p) dc1.v(vsweep)/(dc1.i(Vmeas)) dc2.v(vsweep)/(dc2.i(Vmeas)) dc3.v(vsweep)/(dc3.i(Vmeas)) dc4.v(vsweep)/(dc4.i(Vmeas)) dc5.v(vsweep)/(dc5.i(Vmeas))

write res_tb_linearity.raw

*quit
.endc

**** end user architecture code
**.ends

* expanding   symbol:  vcr_bisection.sym # of pins=5
** sym_path: /home/santi/heichips26-voltage-controlled-resistor/macros/voltage_controlled_resistors/macros/vcr_bisection/schematic/xschem/vcr_bisection.sym
** sch_path: /home/santi/heichips26-voltage-controlled-resistor/macros/voltage_controlled_resistors/macros/vcr_bisection/schematic/xschem/vcr_bisection.sch
.subckt vcr_bisection Vctrl T1 T2 Vdd Vss
*.ipin T1
*.ipin T2
*.ipin Vctrl
*.ipin Vdd
*.ipin Vss
R1 net1 Vcm 10k
R2 Vcm net2 10k
x4 ib2 Vss vgate Vctrl Vdd Vcm voltage_sum
XM1 T2 vgate T1 Vss sg13_hv_nmos w=15u l=10u ng=2 m=1 mm_ok=1
x1 Vdd T1 Vss net1 ib1 net1 opamp_rtr
x2 Vdd T2 Vss net2 ib3 net2 opamp_rtr
x3 Vdd Vdd Vdd ib1 Vdd Vdd Vss Vss isource_beta
x5 Vdd Vdd Vdd ib2 Vdd Vdd Vss Vss isource_beta
x6 Vdd Vdd Vdd ib3 Vdd Vdd Vss Vss isource_beta
.ends

* expanding   symbol:  voltage_sum.sym # of pins=6
** sym_path: /home/santi/heichips26-voltage-controlled-resistor/macros/voltage_controlled_resistors/macros/vcr_bisection/schematic/xschem/voltage_sum.sym
** sch_path: /home/santi/heichips26-voltage-controlled-resistor/macros/voltage_controlled_resistors/macros/vcr_bisection/schematic/xschem/voltage_sum.sch
.subckt voltage_sum ibias vss vout vin1 vdd vin2
*.iopin vin1
*.iopin vout
*.iopin vin2
*.iopin vss
*.iopin vdd
*.iopin ibias
XR5 net2 vin1 vss rhigh w=2e-6 l=100e-6 m=1 b=0 mm_ok=1
XR2 vout net1 vss rhigh w=2e-6 l=100e-6 m=1 b=0 mm_ok=1
XR3 net2 vin2 vss rhigh w=2e-6 l=100e-6 m=1 b=0 mm_ok=1
XR1 vss net1 vss rhigh w=2e-6 l=100e-6 m=1 b=0 mm_ok=1
x1 vdd net2 vss net1 ibias vout opamp_rtr
.ends

* expanding   symbol:
*+  /home/santi/heichips26-voltage-controlled-resistor/macros/voltage_controlled_resistors/macros/vcr_bisection/macros/opamp_rtr/schematic/xschem/opamp_rtr.sym # of pins=6
** sym_path: /home/santi/heichips26-voltage-controlled-resistor/macros/voltage_controlled_resistors/macros/vcr_bisection/macros/opamp_rtr/schematic/xschem/opamp_rtr.sym
** sch_path: /home/santi/heichips26-voltage-controlled-resistor/macros/voltage_controlled_resistors/macros/vcr_bisection/macros/opamp_rtr/schematic/xschem/opamp_rtr.sch
.subckt opamp_rtr vdd inp vss inn ibias out
*.ipin inp
*.opin out
*.iopin vdd
*.ipin inn
*.ipin ibias
*.iopin vss
XXM6 out1_n inp ncmdiff_n vss sg13_hv_nmos w={w_diff_n} l={l_diff} ng={n_diff_n} m=1 mm_ok=1
XXM1 net1 inn ncmdiff_p ncmdiff_p sg13_hv_pmos w={w_diff_p} l={l_diff} ng={n_diff_p} m=1 mm_ok=1
XXM2 ncmdiff_p inp out1_p ncmdiff_p sg13_hv_pmos w={w_diff_p} l={l_diff} ng={n_diff_p} m=1 mm_ok=1
XXM3 ncmdiff_p vbias_p vdd vdd sg13_hv_pmos w={w_tail_p} l={l_bias} ng={n_tail_p} m=1 mm_ok=1
XXM4 vss net1 net1 vss sg13_hv_nmos w={w_load_n} l={l_load} ng={n_load_n} m=1 mm_ok=1
XXM5 out1_p net1 vss vss sg13_hv_nmos w={w_load_n} l={l_load} ng={n_load_n} m=1 mm_ok=1
XXM7 ncmdiff_n inn net2 vss sg13_hv_nmos w={w_diff_n} l={l_diff} ng={n_diff_n} m=1 mm_ok=1
XXM8 ncmdiff_n ibias vss vss sg13_hv_nmos w={w_tail_n} l={l_bias} ng={n_tail_n} m=1 mm_ok=1
XXM9 vdd net2 out1_n vdd sg13_hv_pmos w={w_load_p} l={l_load} ng={n_load_p} m=1 mm_ok=1
XXM10 net2 net2 vdd vdd sg13_hv_pmos w={w_load_p} l={l_load} ng={n_load_p} m=1 mm_ok=1
XXM25 nswa vbias_p ncmdiff_p ncmdiff_p sg13_hv_pmos w={w_sw_p} l={l_sw} ng={n_sw_p} m=1 mm_ok=1
XXM26 nswa nswa vss vss sg13_hv_nmos w={w_gmn} l={l_bias} ng={n_gmn} m=1 mm_ok=1
XXM27 ncmdiff_n nswa vss vss sg13_hv_nmos w={w_gmn} l={l_bias} ng={n_gmn} m=1 mm_ok=1
XXM28 ncmdiff_n vbias_p nswb vss sg13_hv_nmos w={w_sw_n} l={l_sw} ng={n_sw_n} m=1 mm_ok=1
XXM29 nswb nswb vdd vdd sg13_hv_pmos w={w_gmp} l={l_bias} ng={n_gmp} m=1 mm_ok=1
XXM30 ncmdiff_p nswb vdd vdd sg13_hv_pmos w={w_gmp} l={l_bias} ng={n_gmp} m=1 mm_ok=1
XXM13 out1_n nabn out1_p vss sg13_hv_nmos w={w_ab_n} l={l_ab} ng={n_ab_n} m=1 mm_ok=1
XXM14 out1_p nabp out1_n vdd sg13_hv_pmos w={w_ab_p} l={l_ab} ng={n_ab_p} m=1 mm_ok=1
XXM15 out1_n vbias_p vdd vdd sg13_hv_pmos w={w_ab_src} l={l_bias} ng={n_ab_src} m=1 mm_ok=1
XXM16 out1_p nab_ref vss vss sg13_hv_nmos w={w_ab_snk} l={l_bias} ng={n_ab_snk} m=1 mm_ok=1
XXM23 nab_ref vbias_p vdd vdd sg13_hv_pmos w={w_ab_src} l={l_bias} ng={n_ab_src} m=1 mm_ok=1
XXM24 nab_ref nab_ref vss vss sg13_hv_nmos w={w_ab_snk} l={l_bias} ng={n_ab_snk} m=1 mm_ok=1
XXM17 nabn vbias_p vdd vdd sg13_hv_pmos w={w_ab_src} l={l_bias} ng={n_ab_src} m=1 mm_ok=1
XXM18 nabn nabn net3 vss sg13_hv_nmos w={w_ab_n} l={l_ab} ng={n_ab_n} m=1 mm_ok=1
XXM19 net3 net3 vss vss sg13_hv_nmos w={w_ab_n} l={l_ab} ng={n_ab_n} m=1 mm_ok=1
XXM20 nabp nab_ref vss vss sg13_hv_nmos w={w_ab_snk} l={l_bias} ng={n_ab_snk} m=1 mm_ok=1
XXM21 nabp nabp net4 vdd sg13_hv_pmos w={w_ab_p} l={l_ab} ng={n_ab_p} m=1 mm_ok=1
XXM22 net4 net4 vdd vdd sg13_hv_pmos w={w_ab_p} l={l_ab} ng={n_ab_p} m=1 mm_ok=1
XXM11 out out1_n vdd vdd sg13_hv_pmos w={w_out_p} l={l_out} ng={n_out_p} m=1 mm_ok=1
XXM12 out out1_p vss vss sg13_hv_nmos w={w_out_n} l={l_out} ng={n_out_n} m=1 mm_ok=1
XXB1 ibias ibias vss vss sg13_hv_nmos w={w_bias_n} l={l_bias} ng={n_bias_n} m=1 mm_ok=1
XXB2 vbias_p ibias vss vss sg13_hv_nmos w={w_bias_n} l={l_bias} ng={n_bias_n} m=1 mm_ok=1
XXB3 vbias_p vbias_p vdd vdd sg13_hv_pmos w={w_bias_p} l={l_bias} ng={n_bias_p} m=1 mm_ok=1
**** begin user architecture code

*bias network
.param l_bias=4u
.param w_bias_p=15u
.param n_bias_p=2
.param w_bias_n=5u
.param n_bias_n=2
.param w_ref_n=5u
.param n_ref_n=4
.param w_ref_p=15u
.param n_ref_p=4
*first stage
.param l_diff=2u
.param l_load=4u

.param w_diff_n=5u
.param n_diff_n=4

.param w_diff_p=15u
.param n_diff_p=4

.param w_load_n=5u
.param n_load_n=4

.param w_load_p=15u
.param n_load_p=4

.param w_tail_n=5u
.param n_tail_n=2

.param w_tail_p=15u
.param n_tail_p=2

.param l_sw=1u
.param w_sw_p=15u
.param n_sw_p=2

.param w_sw_n=5u
.param n_sw_n=2

.param w_gmn=5u
.param n_gmn=4

.param w_gmp=15u
.param n_gmp=4

*output control circuit
.param w_ab_src=15u
.param n_ab_src=2
.param w_ab_snk=5u
.param n_ab_snk=2

.param w_ab_n=5u
.param n_ab_n=2
.param w_ab_p=15u
.param n_ab_p=2

.param l_ab=1u

.param w_out_p=60u
.param n_out_p=8
.param w_out_n=20u
.param n_out_n=8
.param l_out=1u

.param r_null=50k
.param c_null=500f

**** end user architecture code
XC3 out net5 cap_cmomf w=13.5e-6 l=21e-6 mmin=1 mmax=4 subblock=0 m=1 mm_ok=1
XC2 out net6 cap_cmomf w=13.5e-6 l=21e-6 mmin=1 mmax=4 subblock=0 m=1 mm_ok=1
XR4 net5 out1_n vss rhigh w=1e-6 l=36e-6 m=1 b=0 mm_ok=1
XR2 net6 out1_p vss rhigh w=1e-6 l=36e-6 m=1 b=0 mm_ok=1
XDUMMY1 ncmdiff_n ncmdiff_n ncmdiff_n vss sg13_hv_nmos w=5u l=0.45u ng=4 m=1 mm_ok=1
XDUMMY2 ncmdiff_n ncmdiff_n ncmdiff_n vss sg13_hv_nmos w=5u l=0.45u ng=2 m=1 mm_ok=1
XDUMMY10 out1_n out1_n out1_n vdd sg13_hv_pmos w=15u l=1u ng=2 m=1 mm_ok=1
XDUMMY11 out1_p out1_p out1_p vss sg13_hv_nmos w=5u l=1u ng=2 m=1 mm_ok=1
XRDUMMY vss vss vss rhigh w=1e-6 l=9e-6 m=2 b=0 mm_ok=1
XDUMMY3 ncmdiff_p ncmdiff_p ncmdiff_p ncmdiff_p sg13_hv_pmos w=15u l=0.4u ng=4 m=1 mm_ok=1
.ends

* expanding   symbol:
*+  /home/santi/heichips26-voltage-controlled-resistor/macros/voltage_controlled_resistors/macros/vcr_bisection/macros/isource_beta/schematic/xschem/isource_beta.sym # of pins=8
** sym_path: /home/santi/heichips26-voltage-controlled-resistor/macros/voltage_controlled_resistors/macros/vcr_bisection/macros/isource_beta/schematic/xschem/isource_beta.sym
** sch_path: /home/santi/heichips26-voltage-controlled-resistor/macros/voltage_controlled_resistors/macros/vcr_bisection/macros/isource_beta/schematic/xschem/isource_beta.sch
.subckt isource_beta b0 vdd b1 out b2 b3 vss b4
*.opin out
*.iopin vdd
*.iopin vss
*.iopin b0
*.iopin b1
*.iopin b2
*.iopin b3
*.iopin b4
XM1 net1 v0 vdd vdd sg13_hv_pmos w=12u l=4u ng=4 m=1 mm_ok=1
XM2 v0 v0 vdd vdd sg13_hv_pmos w=12u l=4u ng=4 m=1 mm_ok=1
XM3 net1 net1 vss vss sg13_hv_nmos w=40u l=4u ng=8 m=1 mm_ok=1
XM4 v0 net1 iref vss sg13_hv_nmos w=40u l=4u ng=8 m=3 mm_ok=1
XM5 out v0 vdd vdd sg13_hv_pmos w=12u l=4u ng=4 m=1 mm_ok=1
XMS1 net2 vdd vdd vdd sg13_hv_pmos w=1u l=10u ng=1 m=1 mm_ok=1
XMS2 net2 net1 vss vss sg13_hv_nmos w=10u l=0.45u ng=2 m=1 mm_ok=1
XMS3 v0 net2 vss vss sg13_hv_nmos w=10u l=0.45u ng=2 m=1 mm_ok=1
XR10 iref net4 vss rppd w=1e-6 l=160e-6 m=1 b=0 mm_ok=1
XR2 net6 vss vss rppd w=1e-6 l=10e-6 m=1 b=0 mm_ok=1
XM6 iref b4 net4 vss sg13_hv_nmos w=16u l=0.45u ng=2 m=1 mm_ok=1
XR3 net5 net6 vss rppd w=1e-6 l=20e-6 m=1 b=0 mm_ok=1
XR4 net3 net5 vss rppd w=1e-6 l=40e-6 m=1 b=0 mm_ok=1
XR5 net4 net3 vss rppd w=1e-6 l=80e-6 m=1 b=0 mm_ok=1
XM7 net4 b3 net3 vss sg13_hv_nmos w=16u l=0.45u ng=2 m=1 mm_ok=1
XM8 net3 b2 net5 vss sg13_hv_nmos w=16u l=0.45u ng=2 m=1 mm_ok=1
XM9 net5 b1 net6 vss sg13_hv_nmos w=16u l=0.45u ng=2 m=1 mm_ok=1
XM10 net6 b0 vss vss sg13_hv_nmos w=16u l=0.45u ng=2 m=1 mm_ok=1
XM11 v0 v0 v0 vss sg13_hv_nmos w=100u l=0.5u ng=20 m=1 mm_ok=1
XM12 vss vss vss vss sg13_hv_nmos w=26u l=0.45u ng=4 m=1 mm_ok=1
XR1 vss vss vss rppd w=1e-6 l=10e-6 m=2 b=0 mm_ok=1
.ends

.GLOBAL GND
.GLOBAL VDD
.end
