** sch_path: /home/noah/Documents/freizeit/heichips/heichips26-voltage-controlled-resistor/macros/heichips26_vcr/macros/switched_capacitor/testbenches/xschem/tb_bandgap_reference_dc.sch
**.subckt tb_bandgap_reference_dc
VDD net3 GND 3.3
XM8 net2 net2 GND GND sg13_hv_nmos w=n_w l=n_l ng=1 m=1 mm_ok=1
XM6 net2 net1 net3 net3 sg13_hv_pmos w=p_w l=p_l ng=1 m=1 mm_ok=1
XM1 net1 net1 net3 net3 sg13_hv_pmos w=p_w l=p_l ng=1 m=1 mm_ok=1
XM2 out net1 net3 net3 sg13_hv_pmos w=p_w l=p_l ng=1 m=1 mm_ok=1
XM3 net1 net2 net4 GND sg13_hv_nmos w=5u l=n_l ng=1 m=1 mm_ok=1
XM4 out out net5 GND sg13_hv_nmos w=n_w l=n_l ng=1 m=1 mm_ok=1
XR1 net5 GND sub! rppd w=2e-6 l=50e-6 m=1 b=0 mm_ok=1
XR2 net4 GND sub! rppd w=2e-6 l=50e-6 m=1 b=0 mm_ok=1
**** begin user architecture code

.include ../../../netlist/pex/inverter_magic_pex_3.spice
.param temp=27
.options savecurrents klu method=gear reltol=1e-3 abstol=1e-15 gmin=1e-15
.control

save all

* Operating Point Analysis
op
remzerovec
write tb_bandgap_reference_dc.raw
set appendwrite

* DC Sweep
dc VDD 2.5 4 0.01
remzerovec
write tb_bandgap_reference_dc.raw
set appendwrite

* Plotting
plot out 0

* Measurement
*meas dc Vgsp_at_Vcm when vout=Vcm
*print Vgsp_at_Vcm

* Write Data
*unset appendwrite
*set wr_vecnames
*set wr_singlescale
*wrdata ../plot_simulations/data/tb_bandgap_reference_dc.txt v(vin) v(vout)

*quit
.endc

.lib cornerMOSlv.lib mos_tt
.lib cornerMOShv.lib mos_tt
.lib cornerRES.lib res_typ
.lib cornerDIO.lib dio_tt

.param n_w = 3u
.param n_l = 2.5u
.param p_w = 10u
.param p_l = 2u
.param r_w = 2e-6
.param r_l = 10e-6

**** end user architecture code
**.ends
.GLOBAL GND
.end
