** sch_path: /home/noah/Documents/freizeit/heichips/heichips26-voltage-controlled-resistor/macros/heichips26_vcr/macros/switched_capacitor/testbenches/xschem/tb_current_reference_pmos_dc.sch
**.subckt tb_current_reference_pmos_dc
VDD net1 GND 3.3
vout1 net3 net2 0
.save i(vout1)
x1 net1 net3 GND current_reference_pmos_40uA
Vload net2 GND 1.4
**** begin user architecture code

.include ../../../netlist/pex/inverter_magic_pex_3.spice
.param temp=27
.options savecurrents klu method=gear reltol=1e-3 abstol=1e-15 gmin=1e-15
.control

save all

* Operating Point Analysis
op
remzerovec
write tb_current_reference_pmos_dc.raw
set appendwrite

* DC Sweep
dc VDD 2.5 4 0.01 Vload 0 2.5 0.25
remzerovec
write tb_current_reference_pmos_dc.raw
set appendwrite

meas dc ymax MAX i(vout1)

* Plotting
plot i(vout1) ylimit 0 $&ymax
plot deriv(i(vout1))/$&ymax*100 ylimit 0 4

dc temp -40 85 5 Vload 0 2.25 0.25

meas dc ymax MAX i(vout1)

* Plotting
plot i(vout1) ylimit 0 $&ymax
plot deriv(i(vout1))/$&ymax*1000 ylimit -0.1 0.1

* Measurement
*meas dc Vgsp_at_Vcm when vout=Vcm
*print Vgsp_at_Vcm

* Write Data
*unset appendwrite
*set wr_vecnames
*set wr_singlescale
*wrdata ../plot_simulations/data/tb_current_reference_pmos_dc.txt v(vin) v(vout)

*quit
.endc

.lib cornerMOSlv.lib mos_tt
.lib cornerMOShv.lib mos_tt
.lib cornerRES.lib res_typ
.lib cornerDIO.lib dio_tt

**** end user architecture code
**.ends

* expanding   symbol:  current_reference_pmos_40uA.sym # of pins=3
** sym_path: /home/noah/Documents/freizeit/heichips/heichips26-voltage-controlled-resistor/macros/heichips26_vcr/macros/switched_capacitor/schematic/xschem/current_reference_pmos_40uA.sym
** sch_path: /home/noah/Documents/freizeit/heichips/heichips26-voltage-controlled-resistor/macros/heichips26_vcr/macros/switched_capacitor/schematic/xschem/current_reference_pmos_40uA.sch
.subckt current_reference_pmos_40uA VDD iout VSS
*.iopin VSS
*.iopin VDD
*.iopin iout
XM8 net1 net2 VSS VSS sg13_hv_nmos w=n_w l=n_l ng=1 m=1 mm_ok=1
XM6 net1 net1 VDD VDD sg13_hv_pmos w=p_w l=p_l ng=1 m=1 mm_ok=1
XM1 net2 net1 net3 VDD sg13_hv_pmos w=p_w l=p_l ng=1 m=1 mm_ok=1
XM3 net2 net2 VSS VSS sg13_hv_nmos w=n_w l=n_l ng=1 m=1 mm_ok=1
XR2 VDD net4 VSS rppd w=2e-6 l=21.6e-6 m=1 b=0 mm_ok=1
XR3 net4 net3 VSS rsil w=0.5e-6 l=282e-6 m=1 mm_ok=1
**** begin user architecture code

.param n_w = 6u
.param n_l = 5u
.param p_w = 10u
.param p_l = 2u

**** end user architecture code
XM2 net2 net1 net3 VDD sg13_hv_pmos w=p_w l=p_l ng=1 m=1 mm_ok=1
XM4 net2 net1 net3 VDD sg13_hv_pmos w=p_w l=p_l ng=1 m=1 mm_ok=1
XM5 net2 net1 net3 VDD sg13_hv_pmos w=p_w l=p_l ng=1 m=1 mm_ok=1
XM7 iout net1 VDD VDD sg13_hv_pmos w=p_w l=p_l ng=1 m=1 mm_ok=1
.ends

.GLOBAL GND
.end
