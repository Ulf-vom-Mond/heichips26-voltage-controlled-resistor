** sch_path: /home/noah/Documents/freizeit/heichips/heichips26-voltage-controlled-resistor/macros/heichips26_vcr/macros/switched_capacitor/testbenches/xschem/current_mirror_tb_dc.schm
**.subckt current_mirror_tb_dc
VDD VDD GND {VDD}
Vgsp net1 GND 0
x4 vin net2 GND nmos_current_mirror1
I0 GND net2 1u
vout net1 vin 0
.save i(vout)
**** begin user architecture code

.include ../../../netlist/pex/inverter_magic_pex_3.spice
.param VDD=3.3
.csparam VDD=VDD
.param Vcm=VDD/2
.csparam Vcm=Vcm
.param temp=27
.param Cload=10p
.param Rload=1k
.options savecurrents klu method=gear reltol=1e-3 abstol=1e-15 gmin=1e-15
.control

save all

* Operating Point Analysis
op
remzerovec
write current_mirror_tb_dc.raw
set appendwrite

* DC Sweep
dc Vgsp 0 $&VDD 1m
remzerovec
write current_mirror_tb_dc.raw
set appendwrite

* Plotting
plot i(Vgsp)
*plot vin

* Measurement
*meas dc Vgsp_at_Vcm when vout=Vcm
*print Vgsp_at_Vcm

* Write Data
*unset appendwrite
*set wr_vecnames
*set wr_singlescale
*wrdata ../plot_simulations/data/current_mirror_tb_dc.txt v(vin) v(vout)

*quit
.endc

.lib cornerMOSlv.lib mos_tt
.lib cornerMOShv.lib mos_tt
.lib cornerRES.lib res_typ
.lib cornerDIO.lib dio_tt

**** end user architecture code
**.ends

* expanding   symbol:  nmos_current_mirror1.sym # of pins=3
** sym_path: /home/noah/Documents/freizeit/heichips/heichips26-voltage-controlled-resistor/macros/heichips26_vcr/macros/switched_capacitor/schematic/xschem/nmos_current_mirror1.sym
** sch_path: /home/noah/Documents/freizeit/heichips/heichips26-voltage-controlled-resistor/macros/heichips26_vcr/macros/switched_capacitor/schematic/xschem/nmos_current_mirror1.sch
.subckt nmos_current_mirror1 i_out i_in VSS
*.ipin i_in
*.opin i_out
*.iopin VSS
XM1 i_out i_in VSS VSS sg13_hv_nmos w=40.0u l=10.0u ng=5 m=1 mm_ok=1
XM2 i_in i_in VSS VSS sg13_hv_nmos w=40.0u l=10.0u ng=5 m=1 mm_ok=1
.ends

.GLOBAL GND
.GLOBAL VDD
.end
