** sch_path: /home/noah/Documents/freizeit/heichips/heichips26-voltage-controlled-resistor/macros/heichips26_vcr/macros/switched_capacitor/testbenches/xschem/tb_voltage_mirror_dc.sch
**.subckt tb_voltage_mirror_dc
VDD VDD GND {VDD}
VS in GND 3.3
I0 VDD net1 10u
x1 net1 nout VDD in GND out voltage_mirror
**** begin user architecture code

.include ../../../netlist/pex/inverter_magic_pex_3.spice
.param VDD = 3.3
.param temp=27
.options savecurrents klu method=gear reltol=1e-3 abstol=1e-15 gmin=1e-15
.control

save all

* Operating Point Analysis
op
remzerovec
write tb_voltage_mirror_dc.raw
set appendwrite

* DC Sweep
dc VS 0 $&VDD 0.01
*dc VS 0 3.3 0.01 VDD 2.3 4.3 0.25
*dc VS 0 $&VDD 0.01 temp -40 80 30
*dc temp -40 85 1
remzerovec
write tb_voltage_mirror_dc.raw
set appendwrite

* Plotting
let vdm = nout-out
let vcm = (nout+out)/2
plot out nout
plot vdm vcm
*plot vcm
plot deriv(vdm)

* Measurement
*meas dc Vgsp_at_Vcm when vout=Vcm
*print Vgsp_at_Vcm

* Write Data
*unset appendwrite
*set wr_vecnames
*set wr_singlescale
*wrdata ../plot_simulations/data/tb_voltage_mirror_dc.txt v(vin) v(vout)

*quit
.endc

.lib cornerMOSlv.lib mos_tt
.lib cornerMOShv.lib mos_tt
.lib cornerRES.lib res_typ
.lib cornerDIO.lib dio_tt

**** end user architecture code
**.ends

* expanding   symbol:  voltage_mirror.sym # of pins=6
** sym_path: /home/noah/Documents/freizeit/heichips/heichips26-voltage-controlled-resistor/macros/heichips26_vcr/macros/switched_capacitor/schematic/xschem/voltage_mirror.sym
** sch_path: /home/noah/Documents/freizeit/heichips/heichips26-voltage-controlled-resistor/macros/heichips26_vcr/macros/switched_capacitor/schematic/xschem/voltage_mirror.sch
.subckt voltage_mirror Ibias nout VDD in VSS out
*.iopin VDD
*.iopin VSS
*.ipin in
*.opin out
*.opin nout
*.ipin Ibias
**** begin user architecture code

.param n_w = 6u
.param n_l = 5u
.param p_w = 10u
.param p_l = 2u

**** end user architecture code
XM1 Ibias Ibias VSS VSS sg13_hv_nmos w=1.9*n_w l=n_l ng=2 m=1 mm_ok=1
XR1 in Ibias GND rhigh w=0.5e-6 l=34e-6 m=1 b=0 mm_ok=1
XM2 net1 net1 VDD VDD sg13_hv_pmos w=p_w l=p_l ng=1 m=1 mm_ok=1
XM3 nout Ibias VSS VSS sg13_hv_nmos w=n_w l=n_l ng=1 m=1 mm_ok=1
XM4 out net1 VDD VDD sg13_hv_pmos w=p_w l=p_l ng=1 m=1 mm_ok=1
XM5 net1 Ibias VSS VSS sg13_hv_nmos w=n_w l=n_l ng=1 m=1 mm_ok=1
XR2 VDD nout GND rhigh w=0.5e-6 l=34e-6 m=1 b=0 mm_ok=1
XR3 out VSS GND rhigh w=0.5e-6 l=34e-6 m=1 b=0 mm_ok=1
.ends

.GLOBAL GND
.GLOBAL VDD
.end
