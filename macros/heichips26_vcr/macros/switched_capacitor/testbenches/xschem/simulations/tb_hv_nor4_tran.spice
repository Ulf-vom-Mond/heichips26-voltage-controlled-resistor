** sch_path: /home/noah/Documents/freizeit/heichips/heichips26-voltage-controlled-resistor/macros/heichips26_vcr/macros/switched_capacitor/testbenches/xschem/tb_hv_nor4_tran.sch
**.subckt tb_hv_nor4_tran
VDD VDD GND {VDD}
vp2 net2 GND PULSE(0 VDD {tdel} {tr} {tf} {period*4} {period*8})
vp1 net1 GND PULSE(0 VDD {tdel} {tr} {tf} {period*8} {period*16})
x1 VDD net1 vin1 GND hv_inverter_40u
x2 VDD net2 vin2 GND hv_inverter_40u
x3 VDD vout net5 GND hv_inverter_40u
x5 VDD vin1 vout vin2 GND vin3 vin4 hv_nor4
vp3 net3 GND PULSE(0 VDD {tdel} {tr} {tf} {period*2} {period*4})
x4 VDD net3 vin3 GND hv_inverter_40u
vp4 net4 GND PULSE(0 VDD {tdel} {tr} {tf} {period} {period*2})
x6 VDD net4 vin4 GND hv_inverter_40u
**** begin user architecture code

.param VDD=3.3
.csparam VDD=VDD
.param Vcm=VDD/2
.param temp=27
.param Cload=10p
.param Rload=1k

.param period = 1n
.param tdel   = {period/2}
.param ton    = {period*2}
.csparam tstop  = {17*period}
.csparam tstep  = {period/100}
.param tr     = {period/100}
.param tf     = {period/100}

.options savecurrents klu method=gear reltol=1e-4 abstol=1e-15 gmin=1e-15
.control

save all

* Operating Point Analysis
op
remzerovec
write tb_hv_nor4_tran.raw
set appendwrite

* Transient Analysis
tran {$&tstep} {$&tstop}
write tb_hv_nor4_tran.raw

* Plotting
plot vin1+16 vin2+12 vin3+8 vin4+4 vout

* Write Data
unset appendwrite
set wr_vecnames
set wr_singlescale
wrdata ../plot_simulations/data/tb_hv_nor4_tran.txt v(vin1) v(vin2) v(vout)

*quit
.endc

.lib cornerMOSlv.lib mos_tt
.lib cornerMOShv.lib mos_tt
.lib cornerRES.lib res_typ
.lib cornerDIO.lib dio_tt

**** end user architecture code
**.ends

* expanding   symbol:  hv_inverter_40u.sym # of pins=4
** sym_path: /home/noah/Documents/freizeit/heichips/heichips26-voltage-controlled-resistor/macros/heichips26_vcr/macros/switched_capacitor/schematic/xschem/hv_inverter_40u.sym
** sch_path: /home/noah/Documents/freizeit/heichips/heichips26-voltage-controlled-resistor/macros/heichips26_vcr/macros/switched_capacitor/schematic/xschem/hv_inverter_40u.sch
.subckt hv_inverter_40u VDD in out VSS
*.ipin in
*.iopin VDD
*.iopin VSS
*.opin out
XM2 out in VSS VSS sg13_hv_nmos w={n_w} l={n_l} ng={ng} m=1 mm_ok=1
XM3 out in VDD VDD sg13_hv_pmos w={p_w} l={p_l} ng={ng} m=1 mm_ok=1
**** begin user architecture code

.param w   = 10u
.param ng  = 4
.param n_ng = ng
.param n_w = {3u*n_ng}
.param n_l = 0.45u
.param p_ng = ng
.param p_w = {10u*p_ng}
.param p_l = 0.4u

**** end user architecture code
.ends

* expanding   symbol:  hv_nor4.sym # of pins=7
** sym_path: /home/noah/Documents/freizeit/heichips/heichips26-voltage-controlled-resistor/macros/heichips26_vcr/macros/switched_capacitor/schematic/xschem/hv_nor4.sym
** sch_path: /home/noah/Documents/freizeit/heichips/heichips26-voltage-controlled-resistor/macros/heichips26_vcr/macros/switched_capacitor/schematic/xschem/hv_nor4.sch
.subckt hv_nor4 VDD in1 out in2 VSS in3 in4
*.ipin in1
*.iopin VDD
*.iopin VSS
*.opin out
*.ipin in2
*.ipin in3
*.ipin in4
**** begin user architecture code

.param w   = 10u
.param ng  = 4
.param n_ng = ng
.param n_w = {3u*n_ng}
.param n_l = 0.45u
.param p_ng = ng
.param p_w = {10u*p_ng}
.param p_l = 0.4u

**** end user architecture code
XM2 out in2 VSS VSS sg13_hv_nmos w={n_w} l={n_l} ng={ng} m=1 mm_ok=1
XM3 net3 in1 VDD VDD sg13_hv_pmos w={p_w} l={p_l} ng={ng} m=1 mm_ok=1
XM1 out in1 VSS VSS sg13_hv_nmos w={n_w} l={n_l} ng={ng} m=1 mm_ok=1
XM4 out in4 net1 VDD sg13_hv_pmos w={p_w} l={p_l} ng={ng} m=1 mm_ok=1
XM5 out in3 VSS VSS sg13_hv_nmos w={n_w} l={n_l} ng={ng} m=1 mm_ok=1
XM6 out in4 VSS VSS sg13_hv_nmos w={n_w} l={n_l} ng={ng} m=1 mm_ok=1
XM7 net1 in4 net2 VDD sg13_hv_pmos w={p_w} l={p_l} ng={ng} m=1 mm_ok=1
XM8 net2 in4 net3 VDD sg13_hv_pmos w={p_w} l={p_l} ng={ng} m=1 mm_ok=1
.ends

.GLOBAL GND
.GLOBAL VDD
.end
