** sch_path: /home/noah/Documents/freizeit/heichips/heichips26-voltage-controlled-resistor/macros/heichips26_vcr/macros/switched_capacitor/schematic/xschem/current_reference_pmos_40uA.sch
.subckt current_reference_pmos_40uA VDD iout VSS
*.PININFO VSS:B VDD:B iout:B
XM8 net1 net2 VSS VSS sg13_hv_nmos w=n_w l=n_l ng=1 m=1 mm_ok=1
XM6 net1 net1 VDD VDD sg13_hv_pmos w=p_w l=p_l ng=1 m=1 mm_ok=1
XM1 net2 net1 net3 VDD sg13_hv_pmos w=p_w l=p_l ng=1 m=1 mm_ok=1
XM3 net2 net2 VSS VSS sg13_hv_nmos w=n_w l=n_l ng=1 m=1 mm_ok=1
XR2 VDD net4 VSS rppd w=2e-6 l=21.6e-6 m=1 b=0 mm_ok=1
XR3 net4 net3 VSS rsil w=0.5e-6 l=282e-6 m=1 mm_ok=1
XM2 net2 net1 net3 VDD sg13_hv_pmos w=p_w l=p_l ng=1 m=1 mm_ok=1
XM4 net2 net1 net3 VDD sg13_hv_pmos w=p_w l=p_l ng=1 m=1 mm_ok=1
XM5 net2 net1 net3 VDD sg13_hv_pmos w=p_w l=p_l ng=1 m=1 mm_ok=1
XM7 iout net1 VDD VDD sg13_hv_pmos w=p_w l=p_l ng=1 m=1 mm_ok=1
**** begin user architecture code

.param n_w = 6u
.param n_l = 5u
.param p_w = 10u
.param p_l = 2u

**** end user architecture code
.ends
