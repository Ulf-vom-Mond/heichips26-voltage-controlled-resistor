* PEX produced on Mi 9. Sep 18:07:30 CEST 2026 using scripts/sak-pex.sh with m=3 and s=1 (extresist threshold=10000 mOhm, minres=1000 mOhm, mindelay=1 ps)
* NGSPICE file created from hv_nor4_pex.ext - technology: ihp-sg13cmos5l

.subckt hv_nor4_pex VDD in1 out in2 VSS in3 in4
X0 VDD in4 a_1858_276# VDD sg13_hv_pmos ad=3.4p pd=20.68u as=1.9p ps=10.38u w=10u l=0.4u
X1 VSS.t17 in2 out VSS.t16 sg13_hv_nmos ad=0.57p pd=3.38u as=0.57p ps=3.38u w=3u l=0.45u
X2 a_758_276# in2 a_n342_276# VDD sg13_hv_pmos ad=3.4p pd=20.68u as=1.9p ps=10.38u w=10u l=0.4u
X3 a_758_276# in3 a_1858_276# VDD sg13_hv_pmos ad=1.9p pd=10.38u as=1.9p ps=10.38u w=10u l=0.4u
X4 VSS.t24 in1 out VSS.t23 sg13_hv_nmos ad=0.57p pd=3.38u as=0.57p ps=3.38u w=3u l=0.45u
X5 a_758_276# in3 a_1858_276# VDD sg13_hv_pmos ad=1.9p pd=10.38u as=3.4p ps=20.68u w=10u l=0.4u
X6 out in2 VSS.t17 VSS.t18 sg13_hv_nmos ad=0.57p pd=3.38u as=0.57p ps=3.38u w=3u l=0.45u
X7 out in1 a_n342_276# VDD sg13_hv_pmos ad=1.9p pd=10.38u as=1.9p ps=10.38u w=10u l=0.4u
X8 VSS.t13 in3 out VSS.t12 sg13_hv_nmos ad=1.02p pd=6.68u as=0.57p ps=3.38u w=3u l=0.45u
X9 a_n342_276# in1 out VDD sg13_hv_pmos ad=3.4p pd=20.68u as=1.9p ps=10.38u w=10u l=0.4u
X10 VSS.t27 in1 out VSS.t26 sg13_hv_nmos ad=1.02p pd=6.68u as=0.57p ps=3.38u w=3u l=0.45u
X11 a_n342_276# in2 a_758_276# VDD sg13_hv_pmos ad=1.9p pd=10.38u as=3.4p ps=20.68u w=10u l=0.4u
X12 a_1858_276# in3 a_758_276# VDD sg13_hv_pmos ad=1.9p pd=10.38u as=1.9p ps=10.38u w=10u l=0.4u
X13 a_1858_276# in4 VDD VDD sg13_hv_pmos ad=1.9p pd=10.38u as=3.4p ps=20.68u w=10u l=0.4u
X14 out in2 VSS.t15 VSS.t14 sg13_hv_nmos ad=0.57p pd=3.38u as=1.02p ps=6.68u w=3u l=0.45u
X15 VSS.t3 in4 out VSS.t2 sg13_hv_nmos ad=0.57p pd=3.38u as=0.57p ps=3.38u w=3u l=0.45u
X16 out in1 a_n342_276# VDD sg13_hv_pmos ad=1.9p pd=10.38u as=3.4p ps=20.68u w=10u l=0.4u
X17 out in4 VSS.t3 VSS.t4 sg13_hv_nmos ad=0.57p pd=3.38u as=0.57p ps=3.38u w=3u l=0.45u
X18 out in1 VSS.t24 VSS.t25 sg13_hv_nmos ad=0.57p pd=3.38u as=0.57p ps=3.38u w=3u l=0.45u
X19 a_1858_276# in3 a_758_276# VDD sg13_hv_pmos ad=3.4p pd=20.68u as=1.9p ps=10.38u w=10u l=0.4u
X20 a_1858_276# in4 VDD VDD sg13_hv_pmos ad=1.9p pd=10.38u as=1.9p ps=10.38u w=10u l=0.4u
X21 VSS.t20 in2 out VSS.t19 sg13_hv_nmos ad=1.02p pd=6.68u as=0.57p ps=3.38u w=3u l=0.45u
X22 a_n342_276# in2 a_758_276# VDD sg13_hv_pmos ad=1.9p pd=10.38u as=1.9p ps=10.38u w=10u l=0.4u
X23 out in3 VSS.t8 VSS.t7 sg13_hv_nmos ad=0.57p pd=3.38u as=1.02p ps=6.68u w=3u l=0.45u
X24 VSS.t10 in3 out VSS.t9 sg13_hv_nmos ad=0.57p pd=3.38u as=0.57p ps=3.38u w=3u l=0.45u
X25 out in4 VSS.t1 VSS.t0 sg13_hv_nmos ad=0.57p pd=3.38u as=1.02p ps=6.68u w=3u l=0.45u
X26 out in1 VSS.t22 VSS.t21 sg13_hv_nmos ad=0.57p pd=3.38u as=1.02p ps=6.68u w=3u l=0.45u
X27 a_758_276# in2 a_n342_276# VDD sg13_hv_pmos ad=1.9p pd=10.38u as=1.9p ps=10.38u w=10u l=0.4u
X28 VDD in4 a_1858_276# VDD sg13_hv_pmos ad=1.9p pd=10.38u as=1.9p ps=10.38u w=10u l=0.4u
X29 out in3 VSS.t10 VSS.t11 sg13_hv_nmos ad=0.57p pd=3.38u as=0.57p ps=3.38u w=3u l=0.45u
X30 a_n342_276# in1 out VDD sg13_hv_pmos ad=1.9p pd=10.38u as=1.9p ps=10.38u w=10u l=0.4u
X31 VSS.t6 in4 out VSS.t5 sg13_hv_nmos ad=1.02p pd=6.68u as=0.57p ps=3.38u w=3u l=0.45u
R0 VSS.n21 VSS.t23 289.19
R1 VSS.n39 VSS.t16 289.19
R2 VSS.t9 VSS.n26 289.19
R3 VSS.n20 VSS.t2 289.19
R4 VSS.n21 VSS.t25 159.459
R5 VSS.n39 VSS.t18 159.459
R6 VSS.n26 VSS.t11 159.459
R7 VSS.t4 VSS.n20 159.459
R8 VSS.n4 VSS.n5 0.0116659
R9 VSS.n4 VSS.n6 0.0118344
R10 VSS.n9 VSS.n4 0.0118345
R11 VSS.n4 VSS.n13 0.0116658
R12 VSS.t0 VSS.n3 43.8369
R13 VSS.n2 VSS.t5 64.8835
R14 VSS.t12 VSS.n13 43.8368
R15 VSS.t14 VSS.n5 43.837
R16 VSS.n1 VSS.t9 32.4564
R17 VSS.t26 VSS.n6 43.8366
R18 VSS.n9 VSS.t19 43.8367
R19 VSS.t23 VSS.t21 32.4558
R20 VSS.t2 VSS.n3 32.4564
R21 VSS.t11 VSS.n13 32.4562
R22 VSS.n2 VSS.t4 32.4495
R23 VSS.n4 VSS.n39 8.5005
R24 VSS.n4 VSS.n26 8.5005
R25 VSS.n4 VSS.n11 3.3842
R26 VSS.n4 VSS.n20 8.5005
R27 VSS.n4 VSS.n21 8.5005
R28 VSS.n46 VSS.n4 8.49051
R29 VSS.n45 VSS.n4 8.49051
R30 VSS.n4 VSS.n15 8.49051
R31 VSS.n4 VSS.n24 8.49051
R32 VSS.n8 VSS.n4 0.205922
R33 VSS.n54 VSS.n4 5.65159
R34 VSS.n4 VSS.n38 5.64915
R35 VSS.n11 VSS.n30 0.0806741
R36 VSS.n4 VSS.n17 4.23287
R37 VSS.n50 VSS.n4 4.22505
R38 VSS.n4 VSS.n18 4.22505
R39 VSS.n4 VSS.n36 4.22499
R40 VSS.n43 VSS.n4 4.22486
R41 VSS.n48 VSS.n4 3.36789
R42 VSS.n4 VSS.n19 3.36789
R43 VSS.n4 VSS.n25 3.36771
R44 VSS.n41 VSS.n4 3.36753
R45 VSS.n12 VSS.n4 0.0824755
R46 VSS.n31 VSS.t6 2.47726
R47 VSS.n64 VSS.t22 2.23778
R48 VSS.n62 VSS.t27 2.23778
R49 VSS.n61 VSS.t15 2.23778
R50 VSS.n59 VSS.t20 2.23778
R51 VSS.t8 VSS.n16 2.23778
R52 VSS.n33 VSS.t13 2.23778
R53 VSS.n32 VSS.t1 2.23778
R54 VSS.n63 VSS.t24 2.23739
R55 VSS.n60 VSS.t17 2.23739
R56 VSS.t10 VSS.n34 2.23739
R57 VSS.n31 VSS.t3 2.23739
R58 VSS.n53 VSS.n52 1.32439
R59 VSS.n10 VSS.n14 1.21561
R60 VSS.n52 VSS.n51 1.07078
R61 VSS.n49 VSS.t24 0.664532
R62 VSS.n42 VSS.t17 0.664532
R63 VSS.n35 VSS.t10 0.664532
R64 VSS.t3 VSS.n29 0.664532
R65 VSS.n51 VSS.t22 0.664159
R66 VSS.n47 VSS.t27 0.664159
R67 VSS.n44 VSS.t15 0.664159
R68 VSS.n40 VSS.t20 0.664159
R69 VSS.n37 VSS.t8 0.664159
R70 VSS.t13 VSS.n27 0.664159
R71 VSS.t1 VSS.n28 0.664159
R72 VSS.t6 VSS.n30 0.664159
R73 VSS.n62 VSS.n61 0.314992
R74 VSS.n33 VSS.n32 0.314992
R75 VSS.n7 VSS.n8 1.70844
R76 VSS.n8 VSS.n22 1.20761
R77 VSS.n64 VSS.n63 0.239975
R78 VSS.n63 VSS.n62 0.239975
R79 VSS.n61 VSS.n60 0.239975
R80 VSS.n60 VSS.n59 0.239975
R81 VSS.n34 VSS.n16 0.239975
R82 VSS.n34 VSS.n33 0.239975
R83 VSS.n32 VSS.n31 0.239975
R84 VSS.n56 VSS.n12 1.12174
R85 VSS.n23 VSS.n10 1.12244
R86 VSS.n11 VSS.n7 0.511135
R87 VSS.n59 VSS.n58 0.157746
R88 VSS.n58 VSS.n16 0.157746
R89 VSS.n55 VSS.n12 1.21597
R90 VSS VSS.n64 0.129615
R91 VSS.n29 VSS.n18 0.122003
R92 VSS.n43 VSS.n42 0.121624
R93 VSS.n36 VSS.n35 0.121496
R94 VSS.n50 VSS.n49 0.121246
R95 VSS.n30 VSS.n19 0.108873
R96 VSS.n41 VSS.n40 0.108261
R97 VSS.n27 VSS.n25 0.10796
R98 VSS.n48 VSS.n47 0.10766
R99 VSS.n49 VSS.n48 0.101457
R100 VSS.n35 VSS.n25 0.101152
R101 VSS.n42 VSS.n41 0.100849
R102 VSS.n29 VSS.n19 0.100244
R103 VSS.n51 VSS.n50 0.0873962
R104 VSS.n37 VSS.n36 0.0871438
R105 VSS.n44 VSS.n43 0.0870174
R106 VSS.n28 VSS.n18 0.0866397
R107 VSS.n58 VSS.n57 0.0854057
R108 VSS.n52 VSS.n4 0.077322
R109 VSS.n28 VSS.n17 0.0745025
R110 VSS.n23 VSS.n22 0.0730625
R111 VSS.n53 VSS.n46 0.0640078
R112 VSS.n55 VSS.n45 0.0640078
R113 VSS.n56 VSS.n15 0.0640078
R114 VSS.n24 VSS.n23 0.0640078
R115 VSS.n38 VSS.n37 0.0633607
R116 VSS.n55 VSS.n54 0.0492377
R117 VSS.n38 VSS.n14 0.0432498
R118 VSS.n47 VSS.n46 0.0417606
R119 VSS.n45 VSS.n44 0.0417606
R120 VSS.n40 VSS.n15 0.0417606
R121 VSS.n27 VSS.n24 0.0417606
R122 VSS.n57 VSS.n56 0.0367813
R123 VSS.n57 VSS.n14 0.0367813
R124 VSS.n22 VSS.n17 0.0330274
R125 VSS.n54 VSS.n53 0.0251189
R126 VSS.n6 VSS.t25 32.456
R127 VSS.n9 VSS.t18 32.456
R128 VSS.n4 VSS.n2 0.0162973
R129 VSS.n1 VSS.t7 43.837
R130 VSS.n4 VSS.n1 0.0116659
R131 VSS.n4 VSS.n3 0.0116659
R132 VSS.n0 VSS.t5 135.173
R133 VSS.n5 VSS.t16 32.4564
R134 VSS.n4 VSS.t21 0.0118344
R135 VSS.n10 VSS.n4 0.0826315
R136 VSS.n4 VSS.n0 0.00100101
R137 VSS.n0 VSS.n7 2.28791
C0 in3 in4 0.16135f
C1 VDD in3 2.60514f
C2 a_758_276# VDD 2.92713f
C3 in1 in2 0.15995f
C4 in1 out 3.28385f
C5 in1 a_n342_276# 1.97498f
C6 a_758_276# in3 1.61145f
C7 out in2 2.66767f
C8 a_n342_276# in2 1.07898f
C9 out a_n342_276# 8.56124f
C10 a_1858_276# out 0.04208f
C11 a_1858_276# a_n342_276# 0.09208f
C12 VDD in1 2.65082f
C13 VDD in2 2.59107f
C14 out in4 2.01297f
C15 VDD out 1.44095f
C16 VDD a_n342_276# 3.2178f
C17 a_1858_276# in4 1.07497f
C18 a_1858_276# VDD 12.5629f
C19 VDD in4 4.5464f
C20 in3 in2 0.16135f
C21 out in3 2.66415f
C22 a_758_276# in2 1.95435f
C23 a_1858_276# in3 1.30611f
C24 a_758_276# out 0.09582f
C25 a_758_276# a_n342_276# 9.54026f
C26 a_1858_276# a_758_276# 9.42401f
C27 out VSS 13.26667f
C28 VDD VSS 4.85585f
C29 a_1858_276# VSS 3.02156f
C30 a_758_276# VSS 1.39769f
C31 a_n342_276# VSS 0.72076f
C32 VSS.t24 VSS 1.39801f
C33 VSS.t17 VSS 1.33436f
.ends
