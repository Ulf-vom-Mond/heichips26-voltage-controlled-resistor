* PEX produced on Do 10. Sep 17:23:41 CEST 2026 using scripts/sak-pex.sh with m=3 and s=1 (extresist threshold=10000 mOhm, minres=1000 mOhm, mindelay=1 ps)
* NGSPICE file created from comp_nmos_pex.ext - technology: ihp-sg13cmos5l

.subckt comp_nmos_pex out - + VDD Ibias VSS
X0 VDD a_n406_62# a_n406_62# VDD sg13_hv_pmos ad=0.38p pd=2.38u as=0.68p ps=4.68u w=2u l=0.4u
X1 a_118_854# a_n406_62# VDD VDD sg13_hv_pmos ad=0.68p pd=4.68u as=0.38p ps=2.38u w=2u l=0.4u
X2 out Ibias VSS.t3 VSS.t4 sg13_hv_nmos ad=0.816p pd=5.48u as=0.456p ps=2.78u w=2.4u l=1.5u
X3 a_n38_62# - a_n406_62# VSS.t5 sg13_hv_nmos ad=0.228p pd=1.58u as=0.408p ps=3.08u w=1.2u l=1.5u
X4 VSS.t3 Ibias a_n38_62# VSS.t2 sg13_hv_nmos ad=0.456p pd=2.78u as=0.816p ps=5.48u w=2.4u l=1.5u
X5 VSS.t1 Ibias Ibias VSS.t0 sg13_hv_nmos ad=0.408p pd=3.08u as=0.408p ps=3.08u w=1.2u l=1.5u
X6 VDD a_118_854# out VDD sg13_hv_pmos ad=0.68p pd=4.68u as=0.68p ps=4.68u w=2u l=0.4u
X7 a_118_854# + a_n38_62# VSS.t2 sg13_hv_nmos ad=0.408p pd=3.08u as=0.228p ps=1.58u w=1.2u l=1.5u
R0 VSS.n3 VSS.t0 93.6293
R1 VSS.t5 VSS.n5 0.00127672
R2 VSS.t2 VSS.n5 18.1399
R3 VSS.n3 VSS.t4 36.1938
R4 VSS.t0 VSS.n2 32.9203
R5 VSS.n18 VSS.n6 17.0005
R6 VSS.n16 VSS.n6 17.0005
R7 VSS.t1 VSS.n20 17.0005
R8 VSS.t1 VSS.n17 17.0005
R9 VSS.n21 VSS.t1 17.0005
R10 VSS.n7 VSS.n6 2.82771
R11 VSS.n19 VSS.n6 5.64988
R12 VSS.n25 VSS.t5 4.2505
R13 VSS.t5 VSS.n8 4.23271
R14 VSS.t5 VSS.n11 3.35886
R15 VSS.t5 VSS.n15 2.376
R16 VSS.t5 VSS.n12 1.7334
R17 VSS.t5 VSS.n23 1.65104
R18 VSS.n1 VSS.n13 1.2114
R19 VSS.n14 VSS.n1 1.19132
R20 VSS.t5 VSS.n10 1.14394
R21 VSS.n9 VSS.t3 0.797094
R22 VSS.n4 VSS.n24 0.76529
R23 VSS.n13 VSS.n0 0.765241
R24 VSS.t5 VSS.n0 0.721943
R25 VSS.t5 VSS.n4 0.721068
R26 VSS.n4 VSS.t3 0.536132
R27 VSS.n0 VSS.t3 0.535423
R28 VSS.n22 VSS.n12 0.417904
R29 VSS.n14 VSS.n12 0.357381
R30 VSS.n24 VSS.n11 0.244896
R31 VSS.n13 VSS.n10 0.23975
R32 VSS.n10 VSS.n9 0.228026
R33 VSS.t5 VSS.n1 0.224409
R34 VSS.n15 VSS.n14 0.182136
R35 VSS.n23 VSS.n22 0.167706
R36 VSS.n24 VSS.n23 0.160709
R37 VSS.n7 VSS.n15 0.176099
R38 VSS.n19 VSS.n11 0.146471
R39 VSS.n9 VSS.n8 0.0741818
R40 VSS.n22 VSS.n8 0.0739289
R41 VSS.n20 VSS.n19 0.0489028
R42 VSS.n7 VSS.n21 0.0647717
R43 VSS.n20 VSS.n18 0.028257
R44 VSS.n21 VSS.n16 0.028257
R45 VSS.n25 VSS.t3 0.0214
R46 VSS.n18 VSS.n17 0.0190047
R47 VSS.n17 VSS.n16 0.0190047
R48 VSS VSS.n25 0.0115
R49 VSS.n6 VSS.n2 0.00162498
R50 VSS.t5 VSS.n3 0.00150097
R51 VSS.t5 VSS.n2 0.00112501
R52 VSS.n5 VSS.t4 37.5046
C0 out Ibias 0.69307f
C1 a_n38_62# VDD 0.01192f
C2 + out 0.01551f
C3 out a_n406_62# 0.01687f
C4 a_n38_62# - 0.10282f
C5 a_n38_62# a_118_854# 0.10198f
C6 out VDD 0.77086f
C7 + Ibias 0.13242f
C8 a_118_854# out 0.60518f
C9 + a_n406_62# 0.0125f
C10 VDD Ibias 0.05565f
C11 a_n38_62# out 0.17218f
C12 a_118_854# Ibias 0.11801f
C13 + VDD 0.02351f
C14 VDD a_n406_62# 1.8704f
C15 + - 0.0868f
C16 - a_n406_62# 0.11332f
C17 a_118_854# + 0.09384f
C18 a_118_854# a_n406_62# 0.20478f
C19 a_n38_62# Ibias 0.51957f
C20 - VDD 0.02377f
C21 a_118_854# VDD 1.18997f
C22 a_n38_62# + 0.10273f
C23 a_n38_62# a_n406_62# 0.10815f
C24 out VSS 3.92089f
C25 VDD VSS 1.73454f
C26 a_n38_62# VSS 1.88997f
C27 a_118_854# VSS 0.3366f
C28 a_n406_62# VSS 0.36449f
C29 VSS.t3 VSS 2.27749f
.ends
