* PEX produced on So 13. Sep 13:08:51 CEST 2026 using scripts/sak-pex.sh with m=3 and s=1 (extresist threshold=10000 mOhm, minres=1000 mOhm, mindelay=1 ps)
* NGSPICE file created from bias_current_generator_pex.ext - technology: ihp-sg13cmos5l

.subckt bias_current_generator_pex 40uA+ 5uA+ VDD VSS 5uA- 10uA- 40uA-
X0 a_n7130_n530# a_n6924_n2088# a_n5924_n2052# VSS.t34 sg13_hv_nmos ad=2.04p pd=12.68u as=1.14p ps=6.38u w=6u l=5u
X1 a_2762_n2088# a_2762_n2088# VSS.t43 VSS.t44 sg13_hv_nmos ad=1.14p pd=6.38u as=1.14p ps=6.38u w=6u l=5u
X2 a_n4682_1540# a_n4818_n530# VSS.t4 rsil l=10u w=0.5u
X3 VDD current_reference_40uA_0.iout 40uA+ VDD sg13_hv_pmos ad=0.95p pd=5.38u as=0.95p ps=5.38u w=5u l=2u
X4 a_n6586_1540# a_n6722_n530# VSS.t9 rsil l=10u w=0.5u
X5 a_n3050_1540# a_n2914_n530# VSS.t24 rsil l=10u w=0.5u
X6 a_n6924_n2088# a_n5924_n2052# VDD VDD sg13_hv_pmos ad=3.4p pd=20.68u as=1.9p ps=10.38u w=10u l=2u
X7 5uA- a_7364_n300# VSS.t54 VSS.t53 sg13_hv_nmos ad=2.04p pd=12.68u as=2.04p ps=12.68u w=6u l=5u
X8 a_n4954_1540# a_n4818_n530# VSS.t1 rsil l=10u w=0.5u
X9 VDD a_4108_n387# a_4108_n387# VDD sg13_hv_pmos ad=0.95p pd=5.38u as=0.95p ps=5.38u w=5u l=2u
X10 VDD current_reference_40uA_0.iout current_reference_40uA_0.iout VDD sg13_hv_pmos ad=0.95p pd=5.38u as=0.95p ps=5.38u w=5u l=2u
X11 VDD a_4108_n387# 5uA+ VDD sg13_hv_pmos ad=0.95p pd=5.38u as=0.95p ps=5.38u w=5u l=2u
X12 VSS.t49 a_206_n2052# a_206_n2052# VSS.t50 sg13_hv_nmos ad=1.14p pd=6.38u as=2.04p ps=12.68u w=6u l=5u
X13 a_n6314_1540# a_n6450_n530# VSS.t21 rsil l=10u w=0.5u
X14 a_n4138_1540# a_n4274_n530# VSS.t22 rsil l=10u w=0.5u
X15 a_n3866_1540# a_n4002_n530# VSS.t25 rsil l=10u w=0.5u
X16 a_n5770_1540# a_n5906_n530# VSS.t11 rsil l=10u w=0.5u
X17 VSS.t36 a_n6924_n2088# a_n6924_n2088# VSS.t35 sg13_hv_nmos ad=1.14p pd=6.38u as=2.04p ps=12.68u w=6u l=5u
X18 a_2762_n2088# a_2762_n2088# VSS.t40 VSS.t41 sg13_hv_nmos ad=1.14p pd=6.38u as=1.14p ps=6.38u w=6u l=5u
X19 a_n5498_1540# a_n5362_n530# VSS.t3 rsil l=10u w=0.5u
X20 a_n2578_1750# VSS.t52 VSS.t51 rppd l=10.95u w=2u
X21 a_n7130_1540# a_n6994_n530# VSS.t0 rsil l=10u w=0.5u
X22 VDD a_4108_n387# a_7364_n300# VDD sg13_hv_pmos ad=1.7p pd=10.68u as=0.95p ps=5.38u w=5u l=2u
X23 a_4108_n387# a_2762_n2088# VSS.t46 VSS.t47 sg13_hv_nmos ad=2.04p pd=12.68u as=1.14p ps=6.38u w=6u l=5u
X24 a_n3322_1540# a_n3186_n530# VSS.t30 rsil l=10u w=0.5u
X25 a_n5226_1540# a_n5090_n530# VSS.t17 rsil l=10u w=0.5u
X26 a_n6858_1540# a_n6722_n530# VSS.t15 rsil l=10u w=0.5u
X27 40uA+ current_reference_40uA_0.iout VDD VDD sg13_hv_pmos ad=0.95p pd=5.38u as=0.95p ps=5.38u w=5u l=2u
X28 a_n7130_n530# a_n6924_n2088# a_n5924_n2052# VSS.t32 sg13_hv_nmos ad=1.14p pd=6.38u as=1.14p ps=6.38u w=6u l=5u
X29 VSS.t40 a_2762_n2088# 10uA- VSS.t39 sg13_hv_nmos ad=1.14p pd=6.38u as=2.04p ps=12.68u w=6u l=5u
X30 a_n4682_1540# a_n4546_n530# VSS.t57 rsil l=10u w=0.5u
X31 a_4108_n387# a_4108_n387# VDD VDD sg13_hv_pmos ad=0.95p pd=5.38u as=0.95p ps=5.38u w=5u l=2u
X32 a_n6586_1540# a_n6450_n530# VSS.t19 rsil l=10u w=0.5u
X33 a_n6042_1540# a_n6178_n530# VSS.t5 rsil l=10u w=0.5u
X34 a_206_n2052# current_reference_40uA_0.iout VDD VDD sg13_hv_pmos ad=0.95p pd=5.38u as=0.95p ps=5.38u w=5u l=2u
X35 a_n3594_1540# a_n3730_n530# VSS.t23 rsil l=10u w=0.5u
X36 a_2762_n2088# current_reference_40uA_0.iout VDD VDD sg13_hv_pmos ad=0.95p pd=5.38u as=0.95p ps=5.38u w=5u l=2u
X37 a_7364_n300# a_4108_n387# VDD VDD sg13_hv_pmos ad=0.95p pd=5.38u as=0.95p ps=5.38u w=5u l=2u
X38 a_n6042_1540# a_n5906_n530# VSS.t2 rsil l=10u w=0.5u
X39 a_n5498_1540# a_n5634_n530# VSS.t6 rsil l=10u w=0.5u
X40 a_n5924_n2052# a_n6924_n2088# a_n7130_n530# VSS.t33 sg13_hv_nmos ad=1.14p pd=6.38u as=1.14p ps=6.38u w=6u l=5u
X41 a_n3866_1540# a_n3730_n530# VSS.t26 rsil l=10u w=0.5u
X42 a_n3322_1540# a_n3458_n530# VSS.t27 rsil l=10u w=0.5u
X43 40uA- a_206_n2052# VSS.t49 VSS.t48 sg13_hv_nmos ad=2.04p pd=12.68u as=1.14p ps=6.38u w=6u l=5u
X44 a_n5226_1540# a_n5362_n530# VSS.t12 rsil l=10u w=0.5u
X45 VDD current_reference_40uA_0.iout a_206_n2052# VDD sg13_hv_pmos ad=0.95p pd=5.38u as=0.95p ps=5.38u w=5u l=2u
X46 a_n4954_1540# a_n5090_n530# VSS.t18 rsil l=10u w=0.5u
X47 a_7364_n300# a_7364_n300# VSS.t56 VSS.t55 sg13_hv_nmos ad=2.04p pd=12.68u as=2.04p ps=12.68u w=6u l=5u
X48 a_n7130_1540# a_n7130_n530# VSS.t7 rsil l=10u w=0.5u
X49 a_n6858_1540# a_n6994_n530# VSS.t8 rsil l=10u w=0.5u
X50 a_n3050_1540# a_n3186_n530# VSS.t38 rsil l=10u w=0.5u
X51 current_reference_40uA_0.iout current_reference_40uA_0.iout VDD VDD sg13_hv_pmos ad=0.95p pd=5.38u as=1.7p ps=10.68u w=5u l=2u
X52 5uA+ a_4108_n387# VDD VDD sg13_hv_pmos ad=0.95p pd=5.38u as=0.95p ps=5.38u w=5u l=2u
X53 VSS.t46 a_2762_n2088# a_2762_n2088# VSS.t45 sg13_hv_nmos ad=1.14p pd=6.38u as=1.14p ps=6.38u w=6u l=5u
X54 VDD a_n5924_n2052# a_n5924_n2052# VDD sg13_hv_pmos ad=1.9p pd=10.38u as=3.4p ps=20.68u w=10u l=2u
X55 a_n4410_1540# a_n4274_n530# VSS.t20 rsil l=10u w=0.5u
X56 VSS.t43 a_2762_n2088# a_2762_n2088# VSS.t42 sg13_hv_nmos ad=1.14p pd=6.38u as=1.14p ps=6.38u w=6u l=5u
X57 a_n6314_1540# a_n6178_n530# VSS.t10 rsil l=10u w=0.5u
X58 a_n4410_1540# a_n4546_n530# VSS.t13 rsil l=10u w=0.5u
X59 a_n2578_1750# a_n2914_n530# VSS.t28 rppd l=10.95u w=2u
X60 a_4108_n387# a_4108_n387# VDD VDD sg13_hv_pmos ad=0.95p pd=5.38u as=0.95p ps=5.38u w=5u l=2u
X61 a_n4138_1540# a_n4002_n530# VSS.t14 rsil l=10u w=0.5u
X62 a_n5770_1540# a_n5634_n530# VSS.t16 rsil l=10u w=0.5u
X63 VDD current_reference_40uA_0.iout a_2762_n2088# VDD sg13_hv_pmos ad=0.95p pd=5.38u as=0.95p ps=5.38u w=5u l=2u
X64 a_n5924_n2052# a_n6924_n2088# a_n7130_n530# VSS.t31 sg13_hv_nmos ad=1.14p pd=6.38u as=2.04p ps=12.68u w=6u l=5u
X65 a_n3594_1540# a_n3458_n530# VSS.t29 rsil l=10u w=0.5u
X66 VDD a_4108_n387# a_4108_n387# VDD sg13_hv_pmos ad=0.95p pd=5.38u as=0.95p ps=5.38u w=5u l=2u
X67 current_reference_40uA_0.iout a_n6924_n2088# VSS.t36 VSS.t37 sg13_hv_nmos ad=2.04p pd=12.68u as=1.14p ps=6.38u w=6u l=5u
R0 VSS.n29 VSS.t47 787.47
R1 VSS.n22 VSS.t42 10.5051
R2 VSS.n22 VSS.t41 24.7084
R3 VSS.n22 VSS.t37 32.355
R4 VSS.t48 VSS.n22 32.355
R5 VSS.n22 VSS.t50 32.3549
R6 VSS.n22 VSS.n29 6.39091
R7 VSS.t51 VSS.n25 51.5441
R8 VSS.t8 VSS.n73 41.2968
R9 VSS.n74 VSS.t15 41.2968
R10 VSS.n75 VSS.t21 41.2968
R11 VSS.t16 VSS.n64 41.2968
R12 VSS.t6 VSS.n76 41.2968
R13 VSS.n78 VSS.t17 41.2968
R14 VSS.t1 VSS.n65 41.2968
R15 VSS.t0 VSS.n63 41.2962
R16 VSS.n62 VSS.t9 41.2962
R17 VSS.n60 VSS.t10 41.2962
R18 VSS.n59 VSS.t5 41.2962
R19 VSS.n58 VSS.t2 41.2962
R20 VSS.t11 VSS.n57 41.2962
R21 VSS.t12 VSS.n56 41.2962
R22 VSS.t18 VSS.n55 41.2962
R23 VSS.n28 VSS.n22 0.00227203
R24 VSS.n80 VSS.t33 37.8333
R25 VSS.n25 VSS.t35 14.4381
R26 VSS.n86 VSS.t7 35.0309
R27 VSS.t24 VSS.n27 15.0394
R28 VSS.n79 VSS.t4 30.0871
R29 VSS.t4 VSS.n54 30.0871
R30 VSS.t57 VSS.n53 30.0871
R31 VSS.t22 VSS.n66 30.0871
R32 VSS.n81 VSS.t14 30.0871
R33 VSS.t14 VSS.n52 30.0871
R34 VSS.t26 VSS.n67 30.0871
R35 VSS.t23 VSS.n82 30.0871
R36 VSS.n83 VSS.t29 30.0871
R37 VSS.t29 VSS.n51 30.0871
R38 VSS.t38 VSS.n85 30.0871
R39 VSS.n27 VSS.t38 30.6264
R40 VSS.n85 VSS.t30 30.0865
R41 VSS.n83 VSS.t23 30.0865
R42 VSS.n82 VSS.t26 30.0865
R43 VSS.n67 VSS.t25 30.0865
R44 VSS.n81 VSS.t22 30.0865
R45 VSS.t20 VSS.n66 30.0865
R46 VSS.n79 VSS.t1 30.0865
R47 VSS.n54 VSS.t57 30.0865
R48 VSS.t13 VSS.n53 30.0865
R49 VSS.t25 VSS.n52 30.0865
R50 VSS.t27 VSS.n51 30.0865
R51 VSS.n84 VSS.t34 29.426
R52 VSS.t32 VSS.t3 25.2224
R53 VSS.t31 VSS.n61 24.4816
R54 VSS.n28 VSS.t28 14.7863
R55 VSS.n80 VSS.t13 23.8211
R56 VSS.n72 VSS.t20 23.8211
R57 VSS.n84 VSS.t27 23.8211
R58 VSS.t30 VSS.n71 23.8211
R59 VSS.t7 VSS.n63 18.8774
R60 VSS.t15 VSS.n62 18.8774
R61 VSS.t9 VSS.n61 18.8774
R62 VSS.t21 VSS.n60 18.8774
R63 VSS.t10 VSS.n59 18.8774
R64 VSS.t5 VSS.n58 18.8774
R65 VSS.t2 VSS.n57 18.8774
R66 VSS.t3 VSS.n56 18.8774
R67 VSS.t17 VSS.n55 18.8774
R68 VSS.n65 VSS.t18 18.8768
R69 VSS.n78 VSS.t12 18.8768
R70 VSS.n77 VSS.t6 18.8768
R71 VSS.n76 VSS.t16 18.8768
R72 VSS.n64 VSS.t11 18.8768
R73 VSS.n75 VSS.t19 18.8768
R74 VSS.n74 VSS.t8 18.8768
R75 VSS.n73 VSS.t0 18.8768
R76 VSS.t34 VSS.n71 18.2163
R77 VSS.n46 VSS.n26 5.66622
R78 VSS.n44 VSS.n101 17.0005
R79 VSS.n104 VSS.n44 17.0005
R80 VSS.n43 VSS.n105 17.0005
R81 VSS.n43 VSS.n103 17.0005
R82 VSS.n102 VSS.n42 17.0005
R83 VSS.n47 VSS.n42 17.0005
R84 VSS.n22 VSS.n110 17.0005
R85 VSS.n22 VSS.n111 17.0005
R86 VSS.n22 VSS.n148 17.0005
R87 VSS.n22 VSS.n149 17.0005
R88 VSS.n22 VSS.n150 17.0005
R89 VSS.n22 VSS.n151 17.0005
R90 VSS.n22 VSS.n152 17.0005
R91 VSS.n22 VSS.n156 17.0005
R92 VSS.n22 VSS.n157 17.0005
R93 VSS.n22 VSS.n158 17.0005
R94 VSS.n22 VSS.n159 17.0005
R95 VSS.n22 VSS.n160 17.0005
R96 VSS.n22 VSS.n161 17.0005
R97 VSS.n22 VSS.n162 17.0005
R98 VSS.n22 VSS.n163 17.0005
R99 VSS.n22 VSS.n164 17.0005
R100 VSS.n22 VSS.n165 17.0005
R101 VSS.n22 VSS.n166 17.0005
R102 VSS.n30 VSS.n153 17.0005
R103 VSS.n22 VSS.n127 17.0005
R104 VSS.n22 VSS.n126 17.0005
R105 VSS.n22 VSS.n125 17.0005
R106 VSS.n22 VSS.n124 17.0005
R107 VSS.n22 VSS.n123 17.0005
R108 VSS.n22 VSS.n122 17.0005
R109 VSS.n22 VSS.n121 17.0005
R110 VSS.n22 VSS.n120 17.0005
R111 VSS.n22 VSS.n119 17.0005
R112 VSS.n22 VSS.n118 17.0005
R113 VSS.n22 VSS.n117 17.0005
R114 VSS.n22 VSS.n116 17.0005
R115 VSS.n22 VSS.n115 17.0005
R116 VSS.n22 VSS.n114 17.0005
R117 VSS.n22 VSS.n113 17.0005
R118 VSS.n22 VSS.n112 17.0005
R119 VSS.n144 VSS.t56 17.0005
R120 VSS.t56 VSS.n135 17.0005
R121 VSS.t56 VSS.n136 17.0005
R122 VSS.t56 VSS.n134 17.0005
R123 VSS.t56 VSS.n137 17.0005
R124 VSS.t56 VSS.n133 17.0005
R125 VSS.t56 VSS.n138 17.0005
R126 VSS.t56 VSS.n132 17.0005
R127 VSS.t56 VSS.n139 17.0005
R128 VSS.t56 VSS.n131 17.0005
R129 VSS.t56 VSS.n140 17.0005
R130 VSS.t56 VSS.n130 17.0005
R131 VSS.t56 VSS.n141 17.0005
R132 VSS.t56 VSS.n129 17.0005
R133 VSS.t56 VSS.n142 17.0005
R134 VSS.t56 VSS.n128 17.0005
R135 VSS.t56 VSS.n143 17.0005
R136 VSS.n183 VSS.t54 17.0005
R137 VSS.t54 VSS.n174 17.0005
R138 VSS.t54 VSS.n175 17.0005
R139 VSS.t54 VSS.n173 17.0005
R140 VSS.t54 VSS.n176 17.0005
R141 VSS.t54 VSS.n172 17.0005
R142 VSS.t54 VSS.n177 17.0005
R143 VSS.t54 VSS.n171 17.0005
R144 VSS.t54 VSS.n178 17.0005
R145 VSS.t54 VSS.n170 17.0005
R146 VSS.t54 VSS.n179 17.0005
R147 VSS.t54 VSS.n169 17.0005
R148 VSS.t54 VSS.n180 17.0005
R149 VSS.t54 VSS.n168 17.0005
R150 VSS.t54 VSS.n181 17.0005
R151 VSS.t54 VSS.n167 17.0005
R152 VSS.t54 VSS.n182 17.0005
R153 VSS.t19 VSS.t31 16.8151
R154 VSS.n77 VSS.t32 16.075
R155 VSS.n29 VSS.t53 8.97377
R156 VSS.t44 VSS.n22 10.5122
R157 VSS.t33 VSS.n72 9.809
R158 VSS.n26 VSS.n42 0.00533011
R159 VSS.n86 VSS.n35 4.251
R160 VSS.n35 VSS.n36 0.00149997
R161 VSS.n86 VSS.n37 1.70072
R162 VSS.n37 VSS.n39 0.00276624
R163 VSS.n39 VSS.n31 0.00158329
R164 VSS.n26 VSS.n22 0.00316505
R165 VSS.n22 VSS.n71 8.5005
R166 VSS.n22 VSS.n84 8.5005
R167 VSS.n22 VSS.n72 8.5005
R168 VSS.n22 VSS.n80 8.5005
R169 VSS.n22 VSS.n23 0.807762
R170 VSS.n22 VSS.n100 8.48664
R171 VSS.n22 VSS.n50 8.48664
R172 VSS.n22 VSS.n49 8.48664
R173 VSS.n22 VSS.n48 8.48664
R174 VSS.n90 VSS.n33 8.46995
R175 VSS.n91 VSS.n34 8.46995
R176 VSS.n92 VSS.n36 8.46995
R177 VSS.n93 VSS.n38 8.46995
R178 VSS.n94 VSS.n39 8.46995
R179 VSS.n32 VSS.n31 4.17416
R180 VSS.n24 VSS.n22 0.0125709
R181 VSS.n41 VSS.n30 4.25852
R182 VSS.n44 VSS.n22 0.00399838
R183 VSS.n87 VSS.n86 5.66778
R184 VSS.n12 VSS.n11 8.48747
R185 VSS.n22 VSS.n99 5.65502
R186 VSS.n86 VSS.n22 2.42969
R187 VSS.n89 VSS.n88 4.17751
R188 VSS.n22 VSS.n97 3.35969
R189 VSS.n22 VSS.n184 2.82718
R190 VSS.n22 VSS.n146 2.81324
R191 VSS.n22 VSS.n147 2.81302
R192 VSS.n30 VSS.n22 0.0106513
R193 VSS.n69 VSS.t52 2.5005
R194 VSS.n40 VSS.n7 2.18612
R195 VSS.t40 VSS.n190 2.10748
R196 VSS.t46 VSS.n186 2.107
R197 VSS.t49 VSS.n194 2.1068
R198 VSS.t43 VSS.n188 2.10674
R199 VSS.n22 VSS.n70 2.01188
R200 VSS.n22 VSS.n68 1.99469
R201 VSS.n189 VSS.t43 1.72214
R202 VSS.n195 VSS.t49 1.72205
R203 VSS.n187 VSS.t46 1.72178
R204 VSS.n191 VSS.t40 1.72162
R205 VSS.n24 VSS.n32 1.70722
R206 VSS.n188 VSS.n17 1.33476
R207 VSS.n188 VSS.n16 1.3255
R208 VSS.n155 VSS.n8 1.30898
R209 VSS.n190 VSS.n16 1.30573
R210 VSS.n186 VSS.n17 1.29642
R211 VSS.n22 VSS.n51 1.11904
R212 VSS.n22 VSS.n52 1.11904
R213 VSS.n22 VSS.n53 1.11904
R214 VSS.n22 VSS.n54 1.11904
R215 VSS.n22 VSS.n55 1.11904
R216 VSS.n22 VSS.n56 1.11904
R217 VSS.n22 VSS.n57 1.11904
R218 VSS.n22 VSS.n58 1.11904
R219 VSS.n22 VSS.n59 1.11904
R220 VSS.n22 VSS.n60 1.11904
R221 VSS.n22 VSS.n61 1.11904
R222 VSS.n22 VSS.n62 1.11904
R223 VSS.n22 VSS.n63 1.11904
R224 VSS.n22 VSS.n67 1.11904
R225 VSS.n22 VSS.n66 1.11904
R226 VSS.n22 VSS.n65 1.11904
R227 VSS.n22 VSS.n64 1.11904
R228 VSS.n22 VSS.n25 0.660612
R229 VSS.n22 VSS.n27 0.560086
R230 VSS.n22 VSS.n85 1.11904
R231 VSS.n22 VSS.n83 1.11904
R232 VSS.n22 VSS.n82 1.11904
R233 VSS.n22 VSS.n81 1.11904
R234 VSS.n22 VSS.n79 1.11904
R235 VSS.n22 VSS.n78 1.11904
R236 VSS.n22 VSS.n77 1.11904
R237 VSS.n22 VSS.n76 1.11904
R238 VSS.n22 VSS.n75 1.11904
R239 VSS.n22 VSS.n74 1.11904
R240 VSS.n22 VSS.n73 1.11904
R241 VSS.n2 VSS.n192 1.10917
R242 VSS.n40 VSS.n155 1.04629
R243 VSS.n194 VSS.n13 1.04551
R244 VSS.n19 VSS.n95 1.02884
R245 VSS.n192 VSS.n15 1.01452
R246 VSS.n194 VSS.n14 0.962149
R247 VSS.n89 VSS.n20 0.961968
R248 VSS.n108 VSS.t36 0.930509
R249 VSS.n190 VSS.n15 0.922657
R250 VSS.n192 VSS.n14 0.921317
R251 VSS.n185 VSS.n8 0.909233
R252 VSS.n22 VSS.n0 0.886549
R253 VSS.n98 VSS.n10 0.885821
R254 VSS.n19 VSS.n96 0.85624
R255 VSS.n193 VSS.n2 0.846127
R256 VSS.n98 VSS.n13 0.841999
R257 VSS.n22 VSS.n6 0.825196
R258 VSS.n22 VSS.n3 0.825185
R259 VSS.n22 VSS.n1 0.824944
R260 VSS.n96 VSS.n20 0.822498
R261 VSS.n22 VSS.n21 0.785368
R262 VSS.n22 VSS.n9 0.780902
R263 VSS.n107 VSS.n10 0.675567
R264 VSS.n22 VSS.n13 0.656813
R265 VSS.n22 VSS.n15 0.655112
R266 VSS.n143 VSS.n7 0.653623
R267 VSS.n189 VSS.n5 0.604261
R268 VSS.n22 VSS.n14 0.596982
R269 VSS.n4 VSS.n189 0.596848
R270 VSS.n191 VSS.n4 0.59369
R271 VSS.n5 VSS.n187 0.5863
R272 VSS.n22 VSS.n18 0.567243
R273 VSS.n22 VSS.n10 0.56612
R274 VSS.n95 VSS.n70 0.48998
R275 VSS.n22 VSS.n7 0.487126
R276 VSS.n22 VSS.n2 0.422174
R277 VSS.n107 VSS.n68 0.402476
R278 VSS.n193 VSS.n3 0.402459
R279 VSS.n1 VSS.n193 0.399251
R280 VSS.n96 VSS.n21 0.398531
R281 VSS.n195 VSS.n0 0.393341
R282 VSS.n22 VSS.n19 0.390507
R283 VSS.n6 VSS.n185 0.380196
R284 VSS.n22 VSS.n5 0.374429
R285 VSS.n22 VSS.n4 0.374202
R286 VSS.n1 VSS.n195 0.371149
R287 VSS.n187 VSS.n6 0.370679
R288 VSS.n90 VSS.n89 0.369546
R289 VSS.n3 VSS.n191 0.367983
R290 VSS.n9 VSS.n109 0.365535
R291 VSS.n196 VSS.n0 0.364608
R292 VSS.n154 VSS.n18 0.361711
R293 VSS.n30 VSS.n40 0.352177
R294 VSS.n145 VSS.n18 0.33682
R295 VSS.n69 VSS.n68 0.314719
R296 VSS.n9 VSS.n45 0.306034
R297 VSS.n108 VSS.n107 0.291055
R298 VSS.n93 VSS.n92 0.272378
R299 VSS.n109 VSS.n108 0.266014
R300 VSS.n109 VSS.n21 0.253796
R301 VSS.n91 VSS.n90 0.250378
R302 VSS.n92 VSS.n91 0.250378
R303 VSS.n94 VSS.n93 0.250378
R304 VSS.n32 VSS.n94 0.374001
R305 VSS.n70 VSS.n69 0.237056
R306 VSS.n22 VSS.n16 0.208301
R307 VSS.n22 VSS.n17 0.20806
R308 VSS.n186 VSS.n97 0.192304
R309 VSS.n145 VSS.n97 0.0800478
R310 VSS.n182 VSS.n147 0.0796384
R311 VSS.n146 VSS.n144 0.0788058
R312 VSS.n99 VSS.n98 0.0780071
R313 VSS.n11 VSS.n99 0.0691597
R314 VSS.n184 VSS.n183 0.0651119
R315 VSS.n22 VSS.n20 0.062406
R316 VSS.n11 VSS.n100 0.0589413
R317 VSS.n106 VSS.n23 0.2993
R318 VSS.n23 VSS.n101 0.305342
R319 VSS.n106 VSS.n100 0.0589413
R320 VSS.n103 VSS.n102 0.0580385
R321 VSS.n105 VSS.n104 0.0580385
R322 VSS.n153 VSS.n111 0.0555
R323 VSS.n155 VSS.n110 0.0555
R324 VSS.n154 VSS.n147 0.0542999
R325 VSS.n146 VSS.n145 0.0541408
R326 VSS.n45 VSS.n47 0.0495769
R327 VSS.n22 VSS.n8 0.0409228
R328 VSS VSS.n196 0.0393235
R329 VSS.n101 VSS.n50 0.0297206
R330 VSS.n105 VSS.n49 0.0297206
R331 VSS.n102 VSS.n48 0.0297206
R332 VSS.n47 VSS.n48 0.0297206
R333 VSS.n103 VSS.n49 0.0297206
R334 VSS.n104 VSS.n50 0.0297206
R335 VSS.n144 VSS.n112 0.028257
R336 VSS.n143 VSS.n127 0.028257
R337 VSS.n183 VSS.n166 0.028257
R338 VSS.n182 VSS.n148 0.028257
R339 VSS.n135 VSS.n113 0.026715
R340 VSS.n174 VSS.n165 0.026715
R341 VSS.n128 VSS.n126 0.0262009
R342 VSS.n167 VSS.n149 0.0262009
R343 VSS.n136 VSS.n114 0.0251729
R344 VSS.n175 VSS.n164 0.0251729
R345 VSS.n142 VSS.n125 0.0246589
R346 VSS.n181 VSS.n150 0.0246589
R347 VSS.n134 VSS.n115 0.0236308
R348 VSS.n173 VSS.n163 0.0236308
R349 VSS.n129 VSS.n124 0.0231168
R350 VSS.n168 VSS.n151 0.0231168
R351 VSS.n46 VSS.n45 0.022375
R352 VSS.n185 VSS.n184 0.0223674
R353 VSS.n137 VSS.n116 0.0215748
R354 VSS.n141 VSS.n123 0.0215748
R355 VSS.n176 VSS.n162 0.0215748
R356 VSS.n180 VSS.n152 0.0215748
R357 VSS.n139 VSS.n119 0.0210607
R358 VSS.n139 VSS.n120 0.0210607
R359 VSS.n178 VSS.n159 0.0210607
R360 VSS.n178 VSS.n158 0.0210607
R361 VSS.n133 VSS.n117 0.0200327
R362 VSS.n172 VSS.n161 0.0200327
R363 VSS.n131 VSS.n121 0.0195187
R364 VSS.n130 VSS.n122 0.0195187
R365 VSS.n170 VSS.n157 0.0195187
R366 VSS.n169 VSS.n156 0.0195187
R367 VSS.n196 VSS.n46 0.01925
R368 VSS.n132 VSS.n118 0.0190047
R369 VSS.n171 VSS.n160 0.0190047
R370 VSS.n138 VSS.n118 0.0184907
R371 VSS.n177 VSS.n160 0.0184907
R372 VSS.n140 VSS.n121 0.0179766
R373 VSS.n140 VSS.n122 0.0179766
R374 VSS.n179 VSS.n157 0.0179766
R375 VSS.n179 VSS.n156 0.0179766
R376 VSS.n138 VSS.n117 0.0174626
R377 VSS.n177 VSS.n161 0.0174626
R378 VSS.n132 VSS.n119 0.0169486
R379 VSS.n171 VSS.n159 0.0169486
R380 VSS.n131 VSS.n120 0.0164346
R381 VSS.n130 VSS.n123 0.0164346
R382 VSS.n170 VSS.n158 0.0164346
R383 VSS.n169 VSS.n152 0.0164346
R384 VSS.n133 VSS.n116 0.0159206
R385 VSS.n172 VSS.n162 0.0159206
R386 VSS.n137 VSS.n115 0.0143785
R387 VSS.n141 VSS.n124 0.0143785
R388 VSS.n176 VSS.n163 0.0143785
R389 VSS.n180 VSS.n151 0.0143785
R390 VSS.n24 VSS.n95 1.51533
R391 VSS.n41 VSS.n154 0.00444358
R392 VSS.n129 VSS.n125 0.0128364
R393 VSS.n168 VSS.n150 0.0128364
R394 VSS.n134 VSS.n114 0.0123224
R395 VSS.n173 VSS.n164 0.0123224
R396 VSS.n142 VSS.n126 0.0112944
R397 VSS.n181 VSS.n149 0.0112944
R398 VSS.n136 VSS.n113 0.0107804
R399 VSS.n175 VSS.n165 0.0107804
R400 VSS.n128 VSS.n127 0.00975234
R401 VSS.n167 VSS.n148 0.00975234
R402 VSS.n135 VSS.n112 0.00923832
R403 VSS.n174 VSS.n166 0.00923832
R404 VSS.n22 VSS.t55 26.7486
R405 VSS.n22 VSS.n12 0.00361694
R406 VSS.n41 VSS.n111 0.0147356
R407 VSS.n153 VSS.n110 0.0039375
R408 VSS.n38 VSS.n37 0.00339875
R409 VSS.n87 VSS.n33 0.00166667
R410 VSS.n88 VSS.n22 0.00249998
R411 VSS.n31 VSS.n22 0.00224999
R412 VSS.n22 VSS.t39 32.3549
R413 VSS.n44 VSS.n43 0.0015
R414 VSS.n43 VSS.n42 0.0015
R415 VSS.n38 VSS.n36 0.0015
R416 VSS.n35 VSS.n34 0.00149997
R417 VSS.n34 VSS.n33 0.0015
R418 VSS.n88 VSS.n87 0.00133332
R419 VSS.n22 VSS.t45 24.7089
R420 VSS.n28 VSS.t51 10.1685
R421 VSS.n12 VSS.n106 8.48765
C0 a_n3866_n460# a_n3730_n460# 1.0062f
C1 a_n5924_n2052# a_n7130_n530# 2.2693f
C2 a_n6042_1540# a_n6314_1540# 0.08681f
C3 a_n5498_n460# a_n5362_n460# 1.0062f
C4 a_n6924_n2088# a_n4002_n530# 0.03688f
C5 a_n3594_n460# a_n3458_n460# 1.0062f
C6 a_n5634_n530# a_n5906_n530# 0.08681f
C7 a_2762_n2088# VDD 1.31296f
C8 5uA- a_7364_n300# 0.41753f
C9 a_n6586_1540# a_n6586_n460# 0.02083f
C10 a_n5226_n460# a_n5226_1540# 0.02083f
C11 a_n5498_1540# a_n5362_n460# 0.02083f
C12 a_n5090_n460# a_n5226_n460# 1.0062f
C13 a_n6586_n460# a_n6722_n460# 1.0062f
C14 a_n4546_n530# a_n4546_n460# 0.02083f
C15 a_n4954_n460# a_n4954_1540# 0.02083f
C16 a_n5362_n530# a_n5362_n460# 0.02083f
C17 a_n6924_n2088# a_n4818_n530# 0.02909f
C18 a_n3866_n460# a_n4002_n460# 1.0062f
C19 a_n6924_n2088# a_n5924_n2052# 3.27191f
C20 a_n6450_n530# a_n6722_n530# 0.08681f
C21 a_n6586_n460# a_n6722_n530# 0.02083f
C22 a_2762_n2088# 10uA- 0.43261f
C23 a_n3322_1540# a_n3050_1540# 0.08681f
C24 a_n4138_1540# a_n4410_1540# 0.08681f
C25 5uA- a_4108_n387# 0.05193f
C26 a_n4138_1540# a_n3866_1540# 0.08681f
C27 a_n4274_n530# a_n4138_n460# 0.02083f
C28 a_n6924_n2088# a_n2578_n440# 0.03103f
C29 a_7364_n300# 5uA+ 0.06276f
C30 a_n4954_1540# a_n4682_1540# 0.08681f
C31 a_n5362_n460# a_n5226_n460# 1.0062f
C32 a_n2578_n440# a_n2578_1750# 0.08019f
C33 a_n5090_n460# a_n5090_n530# 0.02083f
C34 a_n3050_1540# a_n2914_n460# 0.02083f
C35 a_n3594_n460# a_n3730_n460# 1.0062f
C36 a_n5906_n530# a_n5770_n460# 0.02083f
C37 a_n6586_1540# a_n6858_1540# 0.08681f
C38 a_n3050_1540# a_n2578_n440# 0.01487f
C39 a_n4682_n460# a_n4818_n530# 0.02083f
C40 a_n6586_1540# a_n6314_1540# 0.08681f
C41 a_n3050_1540# a_n3050_n460# 0.02083f
C42 a_n3458_n530# a_n3458_n460# 0.02083f
C43 a_n6722_n530# a_n6722_n460# 0.02083f
C44 a_n6858_1540# a_n6722_n460# 0.02083f
C45 a_n5906_n530# a_n5906_n460# 0.02083f
C46 a_n3866_n460# a_n4002_n530# 0.02083f
C47 a_n5090_n460# a_n5226_1540# 0.02083f
C48 a_n4410_1540# a_n4682_1540# 0.08681f
C49 a_n6314_n460# a_n6450_n460# 1.0062f
C50 a_n6924_n2088# a_n5634_n530# 0.04393f
C51 a_4108_n387# a_7364_n300# 1.32289f
C52 a_n4682_n460# a_n4682_1540# 0.02083f
C53 a_n4410_1540# a_n4410_n460# 0.02083f
C54 a_n4138_n460# a_n4274_n460# 1.0062f
C55 a_n5924_n2052# a_n2914_n460# 0.01706f
C56 a_n3594_n460# a_n3730_n530# 0.02083f
C57 a_4108_n387# 5uA+ 0.71309f
C58 a_n5924_n2052# a_n2578_n440# 0.08782f
C59 a_n6924_n2088# current_reference_40uA_0.iout 1.1031f
C60 a_n5924_n2052# a_n3050_n460# 0.01555f
C61 a_n4274_n530# a_n4274_n460# 0.02083f
C62 a_n6450_n530# a_n6178_n530# 0.08681f
C63 a_n6924_n2088# a_n5362_n530# 0.04393f
C64 a_n3866_n460# a_n3866_1540# 0.02083f
C65 a_n4954_1540# a_n4818_n460# 0.02083f
C66 a_n2578_n440# a_n2914_n460# 0.35347f
C67 a_n3594_1540# a_n3322_1540# 0.08681f
C68 a_n3322_1540# a_n3322_n460# 0.02083f
C69 a_n5924_n2052# a_n3322_n460# 0.01583f
C70 a_n3594_1540# a_n3866_1540# 0.08681f
C71 a_n2914_n460# a_n3050_n460# 1.0062f
C72 a_n4274_n530# a_n4546_n530# 0.08681f
C73 a_n4954_n460# a_n4818_n460# 1.0062f
C74 a_n7130_1540# a_n6994_n460# 0.02083f
C75 a_n3458_n530# a_n3186_n530# 0.08681f
C76 a_n6924_n2088# a_n2142_n440# 0.03162f
C77 a_n6042_1540# a_n6042_n460# 0.02083f
C78 a_n2142_n440# a_n2578_1750# 0.08019f
C79 a_n4818_n530# a_n4818_n460# 0.02083f
C80 a_n2914_n530# a_n3186_n530# 0.08772f
C81 a_n4682_n460# a_n4818_n460# 1.0062f
C82 a_n6994_n460# a_n7130_n460# 1.0062f
C83 a_n7130_1540# a_n6858_1540# 0.08681f
C84 a_n3186_n460# a_n3186_n530# 0.02083f
C85 a_n4682_n460# a_n4546_n460# 1.0062f
C86 a_n6450_n530# a_n6314_n460# 0.02083f
C87 a_n6178_n460# a_n6314_1540# 0.02083f
C88 a_n4138_n460# a_n4002_n460# 1.0062f
C89 a_n6924_n2088# VDD 1.81762f
C90 a_n6924_n2088# a_n6450_n530# 0.04393f
C91 a_n2578_1750# VDD 0.02111f
C92 a_n4546_n460# a_n4682_1540# 0.02083f
C93 a_n3458_n530# a_n3730_n530# 0.08681f
C94 a_n4410_n460# a_n4546_n460# 1.0062f
C95 a_n2142_n440# a_n5924_n2052# 0.13335f
C96 current_reference_40uA_0.iout a_4108_n387# 0.09281f
C97 a_n6994_n460# a_n6994_n530# 0.02083f
C98 a_n3594_n460# a_n5924_n2052# 0.01614f
C99 40uA+ current_reference_40uA_0.iout 0.65033f
C100 a_n5498_n460# a_n5634_n530# 0.02083f
C101 a_7364_n300# VDD 0.66005f
C102 a_n6042_n460# a_n5906_n460# 1.0062f
C103 a_n6858_n460# a_n6722_n460# 1.0062f
C104 a_n6858_n460# a_n6994_n460# 1.0062f
C105 a_n6924_n2088# a_n5090_n530# 0.03832f
C106 a_n5498_n460# a_n5498_1540# 0.02083f
C107 VDD 5uA+ 0.45115f
C108 40uA+ a_206_n2052# 0.06282f
C109 a_n5924_n2052# VDD 8.36813f
C110 a_206_n2052# 40uA- 0.43261f
C111 a_n2142_n440# a_n2578_n440# 1.10179f
C112 a_n6994_n530# a_n6722_n530# 0.08681f
C113 a_n6924_n2088# a_n4274_n530# 0.04393f
C114 a_n6924_n2088# a_n3458_n530# 0.04393f
C115 a_n6858_n460# a_n6858_1540# 0.02083f
C116 a_n5906_n530# a_n6178_n530# 0.08681f
C117 a_n5634_n530# a_n5362_n530# 0.08681f
C118 a_n4138_1540# a_n4138_n460# 0.02083f
C119 a_n7130_1540# a_n7130_n460# 0.02083f
C120 a_n6314_n460# a_n6314_1540# 0.02083f
C121 a_n6924_n2088# a_n6722_n530# 0.04393f
C122 a_n5090_n530# a_n4954_n460# 0.02083f
C123 a_n6178_n460# a_n6178_n530# 0.02083f
C124 a_n5498_n460# a_n5634_n460# 1.0062f
C125 a_n6924_n2088# a_n2914_n530# 0.05159f
C126 a_n4274_n530# a_n4002_n530# 0.08681f
C127 a_n2578_n440# VDD 0.02348f
C128 a_2762_n2088# a_7364_n300# 0.12525f
C129 a_n4954_1540# a_n5226_1540# 0.08681f
C130 a_n3594_1540# a_n3594_n460# 0.02083f
C131 a_4108_n387# VDD 14.5721f
C132 a_n3730_n460# a_n3730_n530# 0.02083f
C133 a_n5634_n530# a_n5634_n460# 0.02083f
C134 current_reference_40uA_0.iout a_206_n2052# 1.23883f
C135 a_n5090_n530# a_n4818_n530# 0.08681f
C136 40uA+ VDD 0.45115f
C137 a_n5090_n460# a_n4954_n460# 1.0062f
C138 a_n7130_n530# a_n7130_n460# 0.04433f
C139 a_n5924_n2052# a_n3458_n460# 0.016f
C140 a_n5770_1540# a_n5498_1540# 0.08681f
C141 a_n6924_n2088# a_n5906_n530# 0.02686f
C142 a_n6924_n2088# a_n4546_n530# 0.04393f
C143 a_n6924_n2088# a_n3186_n530# 0.04393f
C144 a_n6178_n460# a_n6314_n460# 1.0062f
C145 a_n6450_n530# a_n6450_n460# 0.02083f
C146 a_n5924_n2052# a_n2914_n530# 0.01852f
C147 a_2762_n2088# a_4108_n387# 1.48581f
C148 a_n5362_n530# a_n5226_n460# 0.02083f
C149 current_reference_40uA_0.iout VDD 14.1941f
C150 a_n6586_n460# a_n6450_n460# 1.0062f
C151 a_n3322_1540# a_n3186_n460# 0.02083f
C152 40uA+ a_2762_n2088# 0.06282f
C153 a_n5924_n2052# a_n3186_n460# 0.01568f
C154 a_n6042_1540# a_n5770_1540# 0.08681f
C155 10uA- 40uA- 0.23856f
C156 a_n2914_n530# a_n2914_n460# 0.02534f
C157 a_206_n2052# VDD 0.84713f
C158 a_n4410_1540# a_n4274_n460# 0.02083f
C159 a_n7130_n530# a_n6994_n530# 0.10266f
C160 a_n5770_1540# a_n5634_n460# 0.02083f
C161 a_n2578_n440# a_n2914_n530# 0.08019f
C162 a_n5634_n460# a_n5770_n460# 1.0062f
C163 a_n6178_n460# a_n6042_n460# 1.0062f
C164 a_n6042_1540# a_n5906_n460# 0.02083f
C165 a_n6924_n2088# a_n6178_n530# 0.03884f
C166 a_n3458_n530# a_n3322_n460# 0.02083f
C167 a_n6586_1540# a_n6450_n460# 0.02083f
C168 a_n2142_n440# VDD 0.26474f
C169 a_n3594_1540# a_n3458_n460# 0.02083f
C170 a_n3322_n460# a_n3458_n460# 1.0062f
C171 a_n4546_n530# a_n4818_n530# 0.08681f
C172 a_n6924_n2088# a_n3730_n530# 0.03137f
C173 a_n3186_n460# a_n3050_n460# 1.0062f
C174 a_n4410_n460# a_n4274_n460# 1.0062f
C175 current_reference_40uA_0.iout a_2762_n2088# 0.87054f
C176 a_n6924_n2088# a_n7130_n530# 7.35937f
C177 a_n5770_1540# a_n5770_n460# 0.02083f
C178 a_n6858_n460# a_n6994_n530# 0.02083f
C179 a_n5924_n2052# a_n3730_n460# 0.01634f
C180 a_n6042_n460# a_n6178_n530# 0.02083f
C181 a_n3730_n460# a_n3866_1540# 0.02083f
C182 a_n5090_n530# a_n5362_n530# 0.08681f
C183 a_n3186_n460# a_n3322_n460# 1.0062f
C184 a_n4002_n530# a_n3730_n530# 0.08681f
C185 a_n6924_n2088# a_n6994_n530# 0.02021f
C186 a_n4546_n530# a_n4410_n460# 0.02083f
C187 a_2762_n2088# a_206_n2052# 0.01744f
C188 a_n5498_1540# a_n5226_1540# 0.08681f
C189 a_n4002_n530# a_n4002_n460# 0.02083f
C190 a_n5906_n460# a_n5770_n460# 1.0062f
C191 a_n4138_1540# a_n4002_n460# 0.02083f
C192 a_n3050_n460# a_n3186_n530# 0.02083f
C193 5uA- VSS 6.52805f
C194 10uA- VSS 0.95883f
C195 40uA- VSS 0.95883f
C196 40uA+ VSS 0.75005f
C197 VDD VSS 14.39093f
C198 a_n2914_n530# VSS 2.3365f
C199 a_n3050_1540# VSS 0.88459f
C200 a_n3186_n530# VSS 0.80432f
C201 a_n3322_1540# VSS 0.75699f
C202 a_n3458_n530# VSS 0.80432f
C203 a_n3594_1540# VSS 0.75699f
C204 a_n3730_n530# VSS 0.80842f
C205 a_n3866_1540# VSS 0.75699f
C206 a_n4002_n530# VSS 0.80651f
C207 a_n4138_1540# VSS 0.75699f
C208 a_n4274_n530# VSS 0.80431f
C209 a_n4410_1540# VSS 0.75699f
C210 a_n4546_n530# VSS 0.80431f
C211 a_n4682_1540# VSS 0.75699f
C212 a_n4818_n530# VSS 0.80923f
C213 a_n4954_1540# VSS 0.75699f
C214 a_n5090_n530# VSS 0.80602f
C215 a_n5226_1540# VSS 0.75699f
C216 a_n5362_n530# VSS 0.80431f
C217 a_n5498_1540# VSS 0.75699f
C218 a_n5634_n530# VSS 0.80431f
C219 a_n5770_1540# VSS 0.75699f
C220 a_n5906_n530# VSS 0.81005f
C221 a_n6042_1540# VSS 0.75699f
C222 a_n6178_n530# VSS 0.80585f
C223 a_n6314_1540# VSS 0.75699f
C224 a_n6450_n530# VSS 0.80431f
C225 a_n6586_1540# VSS 0.75699f
C226 a_n6722_n530# VSS 0.80431f
C227 a_n6858_1540# VSS 0.75699f
C228 a_n6994_n530# VSS 0.81087f
C229 a_n7130_n530# VSS 17.42009f
C230 a_n7130_1540# VSS 0.95837f
C231 a_n2578_1750# VSS 2.97422f
C232 VSS.t52 VSS 1.21625f
C233 VSS.t36 VSS 4.26477f
C234 VSS.t54 VSS 5.4619f
C235 VSS.t43 VSS 14.82205f
C236 VSS.t49 VSS 5.12405f
.ends
