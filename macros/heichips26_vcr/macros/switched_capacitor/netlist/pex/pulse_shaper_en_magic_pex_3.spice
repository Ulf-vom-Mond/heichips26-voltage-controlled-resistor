* PEX produced on Mi 16. Sep 13:22:45 CEST 2026 using scripts/sak-pex.sh with m=3 and s=1 (extresist threshold=10000 mOhm, minres=1000 mOhm, mindelay=1 ps)
* NGSPICE file created from pulse_shaper_en_pex.ext - technology: ihp-sg13cmos5l

.subckt pulse_shaper_en_pex out1 nout1 VDD in VSS out2 nout2 en
X0 hv_nor_0.in2 en VSS VSS sg13_hv_nmos ad=0.57p pd=3.38u as=0.57p ps=3.38u w=3u l=0.45u
X1 nout1 out1 VDD VDD sg13_hv_pmos ad=1.9p pd=10.38u as=1.9p ps=10.38u w=10u l=0.4u
X2 VDD out1 nout1 VDD sg13_hv_pmos ad=3.4p pd=20.68u as=1.9p ps=10.38u w=10u l=0.4u
X3 VDD en nout2 VDD sg13_hv_pmos ad=3.4p pd=20.68u as=1.9p ps=10.38u w=10u l=0.4u
X4 hv_nand_0.in1 low_th_inverter_0.vin VSS.t19 VSS.t18 sg13_hv_nmos ad=0.19p pd=1.38u as=0.34p ps=2.68u w=1u l=0.45u
X5 VSS.t39 hv_nor_0.in2 out1 VSS.t38 sg13_hv_nmos ad=0.57p pd=3.38u as=0.57p ps=3.38u w=3u l=0.45u
X6 VSS nout2 out2 VSS sg13_hv_nmos ad=1.02p pd=6.68u as=0.57p ps=3.38u w=3u l=0.45u
X7 a_n342_276# hv_nor_0.in2 VDD VDD sg13_hv_pmos ad=3.4p pd=20.68u as=1.9p ps=10.38u w=10u l=0.4u
X8 nout2 hv_nand_0.in1 VDD VDD sg13_hv_pmos ad=1.9p pd=10.38u as=1.9p ps=10.38u w=10u l=0.4u
X9 VSS.t28 hv_nor_0.in1 out1 VSS.t27 sg13_hv_nmos ad=0.57p pd=3.38u as=0.57p ps=3.38u w=3u l=0.45u
X10 nout2 hv_nand_0.in1 VDD VDD sg13_hv_pmos ad=1.9p pd=10.38u as=3.4p ps=20.68u w=10u l=0.4u
X11 VSS out1 nout1 VSS sg13_hv_nmos ad=0.57p pd=3.38u as=0.57p ps=3.38u w=3u l=0.45u
X12 out1 hv_nor_0.in2 VSS.t39 VSS.t40 sg13_hv_nmos ad=0.57p pd=3.38u as=0.57p ps=3.38u w=3u l=0.45u
X13 VDD en hv_nor_0.in2 VDD sg13_hv_pmos ad=1.9p pd=10.38u as=1.9p ps=10.38u w=10u l=0.4u
X14 out1 hv_nor_0.in1 a_n342_276# VDD sg13_hv_pmos ad=1.9p pd=10.38u as=1.9p ps=10.38u w=10u l=0.4u
X15 hv_nor_0.in1 low_th_inverter_0.vin VSS.t21 VSS.t22 sg13_hv_nmos ad=0.19p pd=1.38u as=0.34p ps=2.68u w=1u l=0.45u
X16 a_1838_n876# hv_nand_0.in1 nout2 VSS.t35 sg13_hv_nmos ad=1.02p pd=6.68u as=0.57p ps=3.38u w=3u l=0.45u
X17 nout1 out1 VSS VSS sg13_hv_nmos ad=0.57p pd=3.38u as=0.57p ps=3.38u w=3u l=0.45u
X18 a_n342_276# hv_nor_0.in1 out1 VDD sg13_hv_pmos ad=3.4p pd=20.68u as=1.9p ps=10.38u w=10u l=0.4u
X19 VSS.t31 hv_nor_0.in1 out1 VSS.t30 sg13_hv_nmos ad=1.02p pd=6.68u as=0.57p ps=3.38u w=3u l=0.45u
X20 out2 nout2 VDD VDD sg13_hv_pmos ad=1.9p pd=10.38u as=1.9p ps=10.38u w=10u l=0.4u
X21 VDD nout2 out2 VDD sg13_hv_pmos ad=3.4p pd=20.68u as=1.9p ps=10.38u w=10u l=0.4u
X22 VDD hv_nor_0.in2 a_n342_276# VDD sg13_hv_pmos ad=1.9p pd=10.38u as=3.4p ps=20.68u w=10u l=0.4u
X23 VDD hv_nand_0.in1 nout2 VDD sg13_hv_pmos ad=1.9p pd=10.38u as=1.9p ps=10.38u w=10u l=0.4u
X24 nout2 en VDD VDD sg13_hv_pmos ad=1.9p pd=10.38u as=3.4p ps=20.68u w=10u l=0.4u
X25 out1 hv_nor_0.in2 VSS.t37 VSS.t36 sg13_hv_nmos ad=0.57p pd=3.38u as=1.02p ps=6.68u w=3u l=0.45u
X26 a_1838_n876# en VSS.t44 VSS.t53 sg13_hv_nmos ad=0.57p pd=3.38u as=0.57p ps=3.38u w=3u l=0.45u
X27 out1 hv_nor_0.in1 a_n342_276# VDD sg13_hv_pmos ad=1.9p pd=10.38u as=3.4p ps=20.68u w=10u l=0.4u
X28 VSS en hv_nor_0.in2 VSS sg13_hv_nmos ad=1.02p pd=6.68u as=0.57p ps=3.38u w=3u l=0.45u
X29 VSS nout2 out2 VSS sg13_hv_nmos ad=0.57p pd=3.38u as=0.57p ps=3.38u w=3u l=0.45u
X30 VDD low_th_inverter_0.vin hv_nor_0.in1 VDD sg13_hv_pmos ad=3.4p pd=20.68u as=1.9p ps=10.38u w=10u l=0.4u
X31 nout1 out1 VSS VSS sg13_hv_nmos ad=0.57p pd=3.38u as=1.02p ps=6.68u w=3u l=0.45u
X32 hv_nand_0.in1 low_th_inverter_0.vin VDD VDD sg13_hv_pmos ad=0.19p pd=1.38u as=0.34p ps=2.68u w=1u l=0.4u
X33 VSS.t24 low_th_inverter_0.vin hv_nor_0.in1 VSS.t23 sg13_hv_nmos ad=0.34p pd=2.68u as=0.19p ps=1.38u w=1u l=0.45u
X34 VSS.t44 en a_1838_n876# VSS.t54 sg13_hv_nmos ad=0.57p pd=3.38u as=0.57p ps=3.38u w=3u l=0.45u
X35 out1 hv_nor_0.in1 VSS.t28 VSS.t29 sg13_hv_nmos ad=0.57p pd=3.38u as=0.57p ps=3.38u w=3u l=0.45u
X36 VDD out1 nout1 VDD sg13_hv_pmos ad=1.9p pd=10.38u as=1.9p ps=10.38u w=10u l=0.4u
X37 VDD hv_nand_0.in1 nout2 VDD sg13_hv_pmos ad=3.4p pd=20.68u as=1.9p ps=10.38u w=10u l=0.4u
X38 nout2 en VDD VDD sg13_hv_pmos ad=1.9p pd=10.38u as=1.9p ps=10.38u w=10u l=0.4u
X39 nout1 out1 VDD VDD sg13_hv_pmos ad=1.9p pd=10.38u as=3.4p ps=20.68u w=10u l=0.4u
X40 VSS.t42 hv_nor_0.in2 out1 VSS.t41 sg13_hv_nmos ad=1.02p pd=6.68u as=0.57p ps=3.38u w=3u l=0.45u
X41 out2 nout2 VSS VSS sg13_hv_nmos ad=0.57p pd=3.38u as=0.57p ps=3.38u w=3u l=0.45u
X42 VDD en hv_nor_0.in2 VDD sg13_hv_pmos ad=3.4p pd=20.68u as=1.9p ps=10.38u w=10u l=0.4u
X43 VDD hv_nor_0.in2 a_n342_276# VDD sg13_hv_pmos ad=1.9p pd=10.38u as=1.9p ps=10.38u w=10u l=0.4u
X44 nout2 hv_nand_0.in1 a_1838_n876# VSS.t32 sg13_hv_nmos ad=0.57p pd=3.38u as=1.02p ps=6.68u w=3u l=0.45u
X45 a_1838_n876# hv_nand_0.in1 nout2 VSS.t33 sg13_hv_nmos ad=0.57p pd=3.38u as=0.57p ps=3.38u w=3u l=0.45u
X46 VSS.t44 en a_1838_n876# VSS.t43 sg13_hv_nmos ad=0.57p pd=3.38u as=1.02p ps=6.68u w=3u l=0.45u
X47 hv_nor_0.in2 en VDD VDD sg13_hv_pmos ad=1.9p pd=10.38u as=1.9p ps=10.38u w=10u l=0.4u
X48 VSS out1 nout1 VSS sg13_hv_nmos ad=1.02p pd=6.68u as=0.57p ps=3.38u w=3u l=0.45u
X49 low_th_inverter_0.vin in VDD VDD sg13_hv_pmos ad=0.102p pd=1.28u as=0.102p ps=1.28u w=0.3u l=0.4u
X50 VDD low_th_inverter_0.vin hv_nand_0.in1 VDD sg13_hv_pmos ad=0.34p pd=2.68u as=0.19p ps=1.38u w=1u l=0.4u
X51 hv_nor_0.in2 en VSS VSS sg13_hv_nmos ad=0.57p pd=3.38u as=1.02p ps=6.68u w=3u l=0.45u
X52 out2 nout2 VSS VSS sg13_hv_nmos ad=0.57p pd=3.38u as=1.02p ps=6.68u w=3u l=0.45u
X53 out1 hv_nor_0.in1 VSS.t26 VSS.t25 sg13_hv_nmos ad=0.57p pd=3.38u as=1.02p ps=6.68u w=3u l=0.45u
X54 VSS en hv_nor_0.in2 VSS sg13_hv_nmos ad=0.57p pd=3.38u as=0.57p ps=3.38u w=3u l=0.45u
X55 a_n342_276# hv_nor_0.in2 VDD VDD sg13_hv_pmos ad=1.9p pd=10.38u as=1.9p ps=10.38u w=10u l=0.4u
X56 VDD en nout2 VDD sg13_hv_pmos ad=1.9p pd=10.38u as=1.9p ps=10.38u w=10u l=0.4u
X57 hv_nor_0.in1 low_th_inverter_0.vin VDD VDD sg13_hv_pmos ad=1.9p pd=10.38u as=3.4p ps=20.68u w=10u l=0.4u
X58 VSS.t21 low_th_inverter_0.vin hv_nand_0.in1 VSS.t20 sg13_hv_nmos ad=0.34p pd=2.68u as=0.19p ps=1.38u w=1u l=0.45u
X59 nout2 hv_nand_0.in1 a_1838_n876# VSS.t34 sg13_hv_nmos ad=0.57p pd=3.38u as=0.57p ps=3.38u w=3u l=0.45u
X60 hv_nor_0.in2 en VDD VDD sg13_hv_pmos ad=1.9p pd=10.38u as=3.4p ps=20.68u w=10u l=0.4u
X61 out2 nout2 VDD VDD sg13_hv_pmos ad=1.9p pd=10.38u as=3.4p ps=20.68u w=10u l=0.4u
X62 VDD nout2 out2 VDD sg13_hv_pmos ad=1.9p pd=10.38u as=1.9p ps=10.38u w=10u l=0.4u
X63 a_n342_276# hv_nor_0.in1 out1 VDD sg13_hv_pmos ad=1.9p pd=10.38u as=1.9p ps=10.38u w=10u l=0.4u
X64 a_1838_n876# en VSS.t44 VSS.t55 sg13_hv_nmos ad=1.02p pd=6.68u as=0.57p ps=3.38u w=3u l=0.45u
X65 low_th_inverter_0.vin in VSS VSS sg13_hv_nmos ad=0.102p pd=1.28u as=0.102p ps=1.28u w=0.3u l=0.45u
R0 VSS.n77 VSS.n76 509.985
R1 VSS.n93 VSS.n92 297.298
R2 VSS.n144 VSS.t27 289.19
R3 VSS.t38 VSS.n143 289.19
R4 VSS.t33 VSS.n124 289.19
R5 VSS.t53 VSS.n118 289.19
R6 VSS.n22 VSS.n27 5.44142
R7 VSS.n12 VSS.n140 191.91
R8 VSS.n20 VSS.n61 29.481
R9 VSS.n144 VSS.t29 159.459
R10 VSS.n143 VSS.t40 159.459
R11 VSS.n124 VSS.t34 159.459
R12 VSS.n118 VSS.t54 159.459
R13 VSS.n34 VSS.n27 0.0119217
R14 VSS.n50 VSS.t55 135.171
R15 VSS.t32 VSS.n2 135.167
R16 VSS.n25 VSS.t25 135.167
R17 VSS.n14 VSS.n21 0.0116658
R18 VSS.n76 VSS.t20 135.167
R19 VSS.n12 VSS.t41 135.154
R20 VSS.n81 VSS.t22 127.028
R21 VSS.t23 VSS.n84 127.028
R22 VSS.t20 VSS.t18 64.9153
R23 VSS.t55 VSS.n5 64.8832
R24 VSS.t35 VSS.n3 64.8832
R25 VSS.t25 VSS.n24 64.8832
R26 VSS.n10 VSS.t32 64.8831
R27 VSS.t36 VSS.n21 43.8365
R28 VSS.n6 VSS.t43 64.883
R29 VSS.t41 VSS.n0 64.8825
R30 VSS.n34 VSS.t30 43.8364
R31 VSS.t22 VSS.n63 56.7573
R32 VSS.n86 VSS.t23 56.7573
R33 VSS.n6 VSS.t53 32.4508
R34 VSS.t27 VSS.n24 32.4508
R35 VSS.t34 VSS.n3 32.4508
R36 VSS.t54 VSS.n5 32.4505
R37 VSS.t40 VSS.n0 32.4503
R38 VSS.n10 VSS.t33 32.45
R39 VSS.n82 VSS.n17 29.2769
R40 VSS.n83 VSS.n82 28.6935
R41 VSS.n62 VSS.n61 28.6935
R42 VSS.n23 VSS.n54 17.0005
R43 VSS.n91 VSS.n90 17.0005
R44 VSS.t26 VSS.n88 17.0005
R45 VSS.n89 VSS.t26 17.0005
R46 VSS.n19 VSS.n20 0.467666
R47 VSS.n57 VSS.n94 17.0005
R48 VSS.n58 VSS.n57 0.00166664
R49 VSS.n14 VSS.n113 17.0005
R50 VSS.n1 VSS.n47 8.5005
R51 VSS.n14 VSS.n48 17.0005
R52 VSS.n14 VSS.n49 17.0005
R53 VSS.n14 VSS.n46 17.0005
R54 VSS.n14 VSS.n45 17.0005
R55 VSS.n14 VSS.n44 17.0005
R56 VSS.n14 VSS.n102 17.0005
R57 VSS.n27 VSS.n44 17.0005
R58 VSS.n27 VSS.n45 17.0005
R59 VSS.n27 VSS.n46 17.0005
R60 VSS.n27 VSS.n49 17.0005
R61 VSS.n27 VSS.n48 17.0005
R62 VSS.n27 VSS.n1 0.00199993
R63 VSS.n27 VSS.n99 17.0005
R64 VSS.n112 VSS.t31 17.0005
R65 VSS.t31 VSS.n107 17.0005
R66 VSS.t31 VSS.n106 17.0005
R67 VSS.t31 VSS.n109 17.0005
R68 VSS.t31 VSS.n105 17.0005
R69 VSS.t31 VSS.n110 17.0005
R70 VSS.t31 VSS.n104 17.0005
R71 VSS.t31 VSS.n111 17.0005
R72 VSS.n112 VSS.t37 17.0005
R73 VSS.n107 VSS.t37 17.0005
R74 VSS.n106 VSS.t37 17.0005
R75 VSS.n109 VSS.t37 17.0005
R76 VSS.n105 VSS.t37 17.0005
R77 VSS.n110 VSS.t37 17.0005
R78 VSS.n104 VSS.t37 17.0005
R79 VSS.n111 VSS.t37 17.0005
R80 VSS.n14 VSS.n115 8.50056
R81 VSS.n14 VSS.n37 0.00199993
R82 VSS.n14 VSS.n36 17.0005
R83 VSS.n14 VSS.n127 17.0005
R84 VSS.n32 VSS.n36 17.0005
R85 VSS.n37 VSS.n126 8.5005
R86 VSS.n16 VSS.n38 8.50184
R87 VSS.n139 VSS.t42 17.0005
R88 VSS.t42 VSS.n135 17.0005
R89 VSS.t42 VSS.n134 17.0005
R90 VSS.t42 VSS.n136 17.0005
R91 VSS.t42 VSS.n133 17.0005
R92 VSS.t42 VSS.n137 17.0005
R93 VSS.t42 VSS.n132 17.0005
R94 VSS.t42 VSS.n138 17.0005
R95 VSS.n68 VSS.n64 17.0005
R96 VSS.n79 VSS.n64 17.0005
R97 VSS.n19 VSS.n86 17.0005
R98 VSS.n19 VSS.n63 17.0005
R99 VSS.n84 VSS.n39 17.0005
R100 VSS.n81 VSS.n39 17.0005
R101 VSS.n28 VSS.n14 0.773023
R102 VSS.n14 VSS.n121 17.0005
R103 VSS.n70 VSS.t19 17.0005
R104 VSS.n140 VSS.n2 16.0009
R105 VSS.n86 VSS.n85 15.4352
R106 VSS.n85 VSS.n63 15.4352
R107 VSS.n83 VSS.n81 14.347
R108 VSS.n84 VSS.n62 14.347
R109 VSS.n14 VSS.n129 8.50125
R110 VSS.n14 VSS.n130 8.50125
R111 VSS.n30 VSS.n23 0.00257105
R112 VSS.n92 VSS.n30 2.42943
R113 VSS.n92 VSS.n55 2.83417
R114 VSS.n55 VSS.n27 0.00266653
R115 VSS.n108 VSS.n27 8.501
R116 VSS.n140 VSS.n11 2.42933
R117 VSS.n11 VSS.n32 0.00292803
R118 VSS.n140 VSS.n16 2.43065
R119 VSS.n77 VSS.n53 2.42957
R120 VSS.n8 VSS.n51 0.00158329
R121 VSS.n52 VSS.n51 0.00199961
R122 VSS.n15 VSS.n14 0.00100001
R123 VSS.n94 VSS.n18 3.40052
R124 VSS.n91 VSS.n35 8.5005
R125 VSS.n27 VSS.n35 4.25075
R126 VSS.n95 VSS.n58 5.66744
R127 VSS.n27 VSS.n144 8.5005
R128 VSS.n14 VSS.n143 8.5005
R129 VSS.n14 VSS.n128 8.5005
R130 VSS.t44 VSS.n42 0.0865876
R131 VSS.n117 VSS.n43 8.5005
R132 VSS.n14 VSS.n118 8.5005
R133 VSS.n14 VSS.n124 8.5005
R134 VSS.n66 VSS.n64 8.49735
R135 VSS.n74 VSS.n64 8.49735
R136 VSS.n40 VSS.n75 8.49735
R137 VSS.n14 VSS.n103 8.49701
R138 VSS.n27 VSS.n98 8.49701
R139 VSS.n78 VSS.n40 8.49563
R140 VSS.n14 VSS.n33 1.69364
R141 VSS.n29 VSS.n23 5.65228
R142 VSS.t19 VSS.n69 8.49201
R143 VSS.n27 VSS.n96 8.49113
R144 VSS.n32 VSS.n131 8.49067
R145 VSS.n14 VSS.n114 8.48933
R146 VSS.n27 VSS.n97 8.48933
R147 VSS.n43 VSS.n122 8.48933
R148 VSS.n28 VSS.n122 0.267977
R149 VSS.n7 VSS.n31 1.10536
R150 VSS.n31 VSS.n8 4.17416
R151 VSS.n42 VSS.n41 4.20063
R152 VSS.n92 VSS.n25 8.14158
R153 VSS.n77 VSS.n17 7.46536
R154 VSS.n20 VSS.n93 5.04604
R155 VSS.n56 VSS.n18 0.00371648
R156 VSS.n50 VSS.n52 4.68227
R157 VSS.n93 VSS.n56 2.83432
R158 VSS.n53 VSS.n40 0.00151425
R159 VSS.n145 VSS.n27 5.66717
R160 VSS.n14 VSS.n22 5.44142
R161 VSS.n51 VSS.n120 5.6032
R162 VSS.n73 VSS.n39 4.24826
R163 VSS.n14 VSS.n125 4.23371
R164 VSS.n19 VSS.n80 3.40184
R165 VSS.n80 VSS.n64 3.40164
R166 VSS.t26 VSS.n87 2.85778
R167 VSS.n19 VSS.n60 2.72532
R168 VSS.n67 VSS.n39 2.71475
R169 VSS.t39 VSS.n14 1.82021
R170 VSS.n27 VSS.t28 1.82
R171 VSS.n65 VSS.n64 1.60601
R172 VSS.t21 VSS.n65 1.34492
R173 VSS.n61 VSS.n39 1.328
R174 VSS.n19 VSS.n62 1.328
R175 VSS.n19 VSS.n83 1.328
R176 VSS.n82 VSS.n39 1.328
R177 VSS.t21 VSS.n60 1.26316
R178 VSS.n71 VSS.n64 1.16423
R179 VSS.n14 VSS.n116 1.02636
R180 VSS.n14 VSS.n9 0.95655
R181 VSS.n14 VSS.n13 0.955405
R182 VSS.n119 VSS.n7 0.90953
R183 VSS.n142 VSS.n26 0.890831
R184 VSS.n14 VSS.n4 0.865147
R185 VSS.n13 VSS.n141 0.8215
R186 VSS.n27 VSS.n26 0.79825
R187 VSS.n14 VSS.n7 0.785258
R188 VSS.n85 VSS.n39 0.783911
R189 VSS.n141 VSS.n4 0.752086
R190 VSS.n119 VSS.n4 0.744814
R191 VSS.n13 VSS.n142 0.710334
R192 VSS.n19 VSS.n17 0.691689
R193 VSS.n26 VSS.n95 0.660969
R194 VSS.n72 VSS.n67 0.423989
R195 VSS.n72 VSS.n71 0.378536
R196 VSS.n9 VSS.n100 0.345539
R197 VSS.n120 VSS.n31 0.464872
R198 VSS.n71 VSS.n70 0.326635
R199 VSS.n117 VSS.n116 0.307101
R200 VSS.t44 VSS.n116 0.306096
R201 VSS.n9 VSS.n123 0.27706
R202 VSS.n67 VSS.t24 0.271659
R203 VSS.n60 VSS.t24 0.218578
R204 VSS.n69 VSS.n65 0.217781
R205 VSS.n59 VSS.t28 0.201881
R206 VSS.t39 VSS.n101 0.201225
R207 VSS.n100 VSS.t39 0.199117
R208 VSS.t28 VSS.n101 0.198424
R209 VSS.n120 VSS.n42 0.412872
R210 VSS.t18 VSS.n64 0.140024
R211 VSS.n28 VSS.n119 0.236083
R212 VSS.n131 VSS.n125 0.0693942
R213 VSS.n29 VSS.n59 0.0422023
R214 VSS.n141 VSS.n125 0.0489963
R215 VSS.n114 VSS.n97 0.0481858
R216 VSS.n114 VSS.n96 0.0445753
R217 VSS.n123 VSS.n121 0.04175
R218 VSS.n123 VSS.n117 0.0321092
R219 VSS.n145 VSS.n59 0.0297991
R220 VSS.n94 VSS.n35 0.0294474
R221 VSS.n88 VSS.n54 0.028257
R222 VSS.n70 VSS.n68 0.028257
R223 VSS.n69 VSS.n68 0.0271959
R224 VSS.n80 VSS.t21 0.0260844
R225 VSS.n142 VSS.n97 0.0243429
R226 VSS.n122 VSS.n121 0.0243429
R227 VSS.n90 VSS.n89 0.0236308
R228 VSS.n131 VSS.n127 0.0216524
R229 VSS.n87 VSS.n35 0.0207632
R230 VSS.n102 VSS.n96 0.0207324
R231 VSS.n74 VSS.n73 0.0197515
R232 VSS.n78 VSS.n66 0.019537
R233 VSS.n139 VSS.n38 0.0194172
R234 VSS.n138 VSS.n36 0.0194172
R235 VSS.n136 VSS.n130 0.0183662
R236 VSS.n103 VSS.n98 0.0174754
R237 VSS.n34 VSS.t29 32.4564
R238 VSS.n14 VSS.n10 0.0166655
R239 VSS.n14 VSS.n0 0.0165363
R240 VSS.n33 VSS.n100 0.0197011
R241 VSS.n27 VSS.n24 0.0162916
R242 VSS.n14 VSS.n3 0.0162916
R243 VSS.n14 VSS.n12 0.0162868
R244 VSS.n21 VSS.t38 32.4564
R245 VSS.n14 VSS.n5 0.0162868
R246 VSS.n14 VSS.n6 0.0162868
R247 VSS.n135 VSS.n115 0.0162643
R248 VSS.n75 VSS.n74 0.0161031
R249 VSS.n75 VSS.n66 0.0161031
R250 VSS VSS.n145 0.0159206
R251 VSS.n90 VSS.n87 0.0159206
R252 VSS.n132 VSS.n126 0.015914
R253 VSS.n133 VSS.n128 0.0152134
R254 VSS.n136 VSS.n129 0.0148631
R255 VSS.n101 VSS.n22 0.12752
R256 VSS.n112 VSS.n47 0.0131923
R257 VSS.n111 VSS.n44 0.0131923
R258 VSS.n134 VSS.n129 0.0131115
R259 VSS.n137 VSS.n128 0.0127611
R260 VSS.n109 VSS.n108 0.0124872
R261 VSS.n89 VSS.n54 0.0123224
R262 VSS.n137 VSS.n126 0.0120605
R263 VSS.n79 VSS.n78 0.0117354
R264 VSS.n134 VSS.n115 0.0117102
R265 VSS.n107 VSS.n48 0.0110769
R266 VSS.n104 VSS.n45 0.0108419
R267 VSS.n105 VSS.n46 0.0103718
R268 VSS.n109 VSS.n49 0.0101368
R269 VSS.n133 VSS.n130 0.00960828
R270 VSS.n103 VSS.n99 0.0089877
R271 VSS.n113 VSS.n98 0.0089877
R272 VSS.n106 VSS.n49 0.00896154
R273 VSS.n132 VSS.n36 0.00890764
R274 VSS.n110 VSS.n46 0.0087265
R275 VSS.n135 VSS.n38 0.00855732
R276 VSS.n110 VSS.n45 0.00825641
R277 VSS.n106 VSS.n48 0.00802137
R278 VSS.n88 VSS.n29 0.0434092
R279 VSS.n108 VSS.n105 0.00661111
R280 VSS.n104 VSS.n44 0.00614103
R281 VSS.n95 VSS.t24 0.00605046
R282 VSS.n107 VSS.n47 0.00590598
R283 VSS.t21 VSS.n79 0.00587109
R284 VSS.n33 VSS.n139 0.0434288
R285 VSS.n138 VSS.n127 0.00540446
R286 VSS.n73 VSS.n72 0.00464999
R287 VSS.n113 VSS.n112 0.0037906
R288 VSS.n111 VSS.n102 0.0037906
R289 VSS.n94 VSS.t24 0.00339474
R290 VSS.n101 VSS.n99 0.00308547
R291 VSS.n91 VSS.n55 0.00283308
R292 VSS.n53 VSS.n19 0.00278546
R293 VSS.n52 VSS.n41 0.00416579
R294 VSS.n14 VSS.n1 0.00199993
R295 VSS.n57 VSS.n56 0.00158327
R296 VSS.n15 VSS.t43 135.173
R297 VSS.n27 VSS.n23 0.00282519
R298 VSS.n58 VSS.n39 0.00133332
R299 VSS.n76 VSS.n64 0.00144293
R300 VSS.n91 VSS.n30 0.00342844
R301 VSS.n43 VSS.n14 0.00168417
R302 VSS.n37 VSS.n32 0.00199993
R303 VSS.n14 VSS.n8 0.00224999
R304 VSS.n40 VSS.n39 0.0022
R305 VSS.n14 VSS.n41 0.00199997
R306 VSS.n14 VSS.n11 0.00357125
R307 VSS.n27 VSS.n25 0.00341431
R308 VSS.n50 VSS.n14 0.00276941
R309 VSS.n14 VSS.n2 0.00272698
R310 VSS.n14 VSS.n16 0.0026862
R311 VSS.n19 VSS.n18 0.00219982
R312 VSS.n15 VSS.t35 135.173
C0 low_th_inverter_0.vin in 0.52991f
C1 a_1838_n876# en 1.22145f
C2 a_1838_n876# hv_nand_0.in1 2.0046f
C3 hv_nor_0.in2 nout1 0.48553f
C4 a_1838_n876# nout2 2.56545f
C5 out1 hv_nor_0.in1 3.38367f
C6 hv_nor_0.in2 a_1838_n876# 0.01413f
C7 hv_nor_0.in1 a_n342_276# 2.4655f
C8 VDD hv_nor_0.in1 5.74515f
C9 out1 a_n342_276# 9.72741f
C10 hv_nor_0.in1 hv_nand_0.in1 0.29147f
C11 VDD out1 4.96855f
C12 out1 en 0.0985f
C13 out1 hv_nand_0.in1 0.78496f
C14 hv_nor_0.in2 hv_nor_0.in1 0.16016f
C15 out1 nout2 0.0262f
C16 hv_nor_0.in2 out1 2.19272f
C17 low_th_inverter_0.vin hv_nor_0.in1 1.12136f
C18 VDD a_n342_276# 8.74197f
C19 out1 low_th_inverter_0.vin 0.03856f
C20 VDD en 8.23008f
C21 VDD hv_nand_0.in1 3.87119f
C22 hv_nand_0.in1 en 0.43817f
C23 VDD nout2 12.0366f
C24 hv_nor_0.in2 a_n342_276# 4.07587f
C25 nout2 en 4.29654f
C26 hv_nor_0.in2 VDD 8.77446f
C27 nout2 hv_nand_0.in1 3.37188f
C28 low_th_inverter_0.vin a_n342_276# 0.03139f
C29 VDD out2 4.40321f
C30 hv_nor_0.in2 en 3.45456f
C31 hv_nor_0.in2 hv_nand_0.in1 0.30954f
C32 VDD low_th_inverter_0.vin 3.27755f
C33 out2 en 0.23576f
C34 low_th_inverter_0.vin hv_nand_0.in1 0.83443f
C35 hv_nor_0.in2 nout2 0.29955f
C36 nout2 out2 4.63931f
C37 out1 nout1 4.63413f
C38 hv_nor_0.in2 out2 0.30844f
C39 VDD in 0.30502f
C40 a_1838_n876# out1 0.01268f
C41 VDD nout1 4.44024f
C42 nout1 en 0.03599f
C43 out2 VSS 5.11278f
C44 nout1 VSS 7.17052f
C45 VDD VSS 10.9702f
C46 a_1838_n876# VSS 3.68926f
C47 a_n342_276# VSS 0.15217f
C48 VSS.t28 VSS 1.64626f
C49 VSS.t19 VSS 1.05992f
C50 VSS.t39 VSS 3.23138f
.ends
