* PEX produced on Fr 11. Sep 21:31:59 CEST 2026 using scripts/sak-pex.sh with m=3 and s=1 (extresist threshold=10000 mOhm, minres=1000 mOhm, mindelay=1 ps)
* NGSPICE file created from current_reference_40uA_pex.ext - technology: ihp-sg13cmos5l

.subckt current_reference_40uA_pex VDD iout VSS
X0 a_4208_3816# a_4344_1746# VSS.t7 rsil l=10u w=0.5u
X1 a_354_1888# a_242_188# a_2662_224# VSS.t12 sg13_hv_nmos ad=1.14p pd=6.38u as=2.04p ps=12.68u w=6u l=5u
X2 a_5840_3816# a_5976_1746# VSS.t35 rsil l=10u w=0.5u
X3 a_6112_3816# a_6248_1746# VSS.t32 rsil l=10u w=0.5u
X4 a_3392_3816# a_3256_1746# VSS.t17 rsil l=10u w=0.5u
X5 a_3664_3816# a_3800_1746# VSS.t4 rsil l=10u w=0.5u
X6 a_5296_3816# a_5160_1746# VSS.t26 rsil l=10u w=0.5u
X7 a_5568_3816# a_5704_1746# VSS.t25 rsil l=10u w=0.5u
X8 a_3392_3816# a_3528_1746# VSS.t5 rsil l=10u w=0.5u
X9 a_3120_3816# a_2984_1746# VSS.t1 rsil l=10u w=0.5u
X10 a_1776_4026# a_2212_1750# VSS.t22 rppd l=10.95u w=2u
X11 a_4752_3816# a_4616_1746# VSS.t21 rsil l=10u w=0.5u
X12 a_5024_3816# a_4888_1746# VSS.t9 rsil l=10u w=0.5u
X13 a_6656_3816# a_6520_1746# VSS.t34 rsil l=10u w=0.5u
X14 a_1776_4026# VSS VSS.t20 rppd l=10.95u w=2u
X15 a_2662_224# a_242_188# a_354_1888# VSS.t13 sg13_hv_nmos ad=1.14p pd=6.38u as=1.14p ps=6.38u w=6u l=5u
X16 a_354_1888# a_242_188# a_2662_224# VSS.t14 sg13_hv_nmos ad=1.14p pd=6.38u as=1.14p ps=6.38u w=6u l=5u
X17 a_3936_3816# a_4072_1746# VSS.t6 rsil l=10u w=0.5u
X18 a_242_188# a_242_188# VSS VSS.t10 sg13_hv_nmos ad=2.04p pd=12.68u as=1.14p ps=6.38u w=6u l=5u
X19 a_3936_3816# a_3800_1746# VSS.t18 rsil l=10u w=0.5u
X20 a_4208_3816# a_4072_1746# VSS.t0 rsil l=10u w=0.5u
X21 VDD a_354_1888# a_242_188# VDD sg13_hv_pmos ad=1.9p pd=10.38u as=3.4p ps=20.68u w=10u l=2u
X22 a_5296_3816# a_5432_1746# VSS.t28 rsil l=10u w=0.5u
X23 a_2848_3816# a_2984_1746# VSS.t16 rsil l=10u w=0.5u
X24 a_3120_3816# a_3256_1746# VSS.t3 rsil l=10u w=0.5u
X25 a_4480_3816# a_4344_1746# VSS.t39 rsil l=10u w=0.5u
X26 a_4752_3816# a_4888_1746# VSS.t23 rsil l=10u w=0.5u
X27 a_2662_224# a_242_188# a_354_1888# VSS.t15 sg13_hv_nmos ad=2.04p pd=12.68u as=1.14p ps=6.38u w=6u l=5u
X28 a_6384_3816# a_6248_1746# VSS.t36 rsil l=10u w=0.5u
X29 a_4480_3816# a_4616_1746# VSS.t38 rsil l=10u w=0.5u
X30 a_5840_3816# a_5704_1746# VSS.t30 rsil l=10u w=0.5u
X31 a_6112_3816# a_5976_1746# VSS.t24 rsil l=10u w=0.5u
X32 VSS a_242_188# iout VSS.t11 sg13_hv_nmos ad=1.14p pd=6.38u as=2.04p ps=12.68u w=6u l=5u
X33 a_3664_3816# a_3528_1746# VSS.t2 rsil l=10u w=0.5u
X34 a_5568_3816# a_5432_1746# VSS.t27 rsil l=10u w=0.5u
X35 a_5024_3816# a_5160_1746# VSS.t19 rsil l=10u w=0.5u
X36 a_6656_3816# a_6792_1746# VSS.t33 rsil l=10u w=0.5u
X37 a_6928_3816# a_2662_224# VSS.t37 rsil l=10u w=0.5u
X38 a_354_1888# a_354_1888# VDD VDD sg13_hv_pmos ad=3.4p pd=20.68u as=1.9p ps=10.38u w=10u l=2u
X39 a_6928_3816# a_6792_1746# VSS.t29 rsil l=10u w=0.5u
X40 a_2848_3816# a_2212_1750# VSS.t8 rsil l=10u w=0.5u
X41 a_6384_3816# a_6520_1746# VSS.t31 rsil l=10u w=0.5u
R0 VSS.t10 VSS 17.8825
R1 VSS.t22 VSS 14.7863
R2 VSS.t13 VSS.n27 37.8333
R3 VSS.n18 VSS.t21 41.2962
R4 VSS.n3 VSS.t23 41.2962
R5 VSS.n16 VSS.t9 41.2962
R6 VSS.n12 VSS.t19 41.2962
R7 VSS.n20 VSS.t28 41.2962
R8 VSS.n15 VSS.t27 41.2962
R9 VSS.n25 VSS.t25 41.2962
R10 VSS.n2 VSS.t30 41.2962
R11 VSS.n6 VSS.t24 41.2962
R12 VSS.n11 VSS.t32 41.2962
R13 VSS.n1 VSS.t31 41.2962
R14 VSS.n23 VSS.t33 41.2962
R15 VSS.n0 VSS.t29 41.6756
R16 VSS.t16 VSS.n31 30.0869
R17 VSS.t8 VSS 15.0392
R18 VSS VSS.t16 30.6262
R19 VSS.n31 VSS.t1 30.0863
R20 VSS.t12 VSS.n29 29.426
R21 VSS.t14 VSS.t26 25.2224
R22 VSS.t1 VSS.n30 23.8211
R23 VSS.n29 VSS.t3 23.8211
R24 VSS.t3 VSS.n14 30.0865
R25 VSS.t17 VSS.n14 30.0871
R26 VSS.n5 VSS.t17 30.0865
R27 VSS.t5 VSS.n5 30.0871
R28 VSS.t2 VSS.n22 30.0865
R29 VSS.n19 VSS.t2 30.0865
R30 VSS.t4 VSS.n19 30.0871
R31 VSS.n4 VSS.t4 30.0865
R32 VSS.t18 VSS.n4 30.0871
R33 VSS.n7 VSS.t18 30.0865
R34 VSS.t6 VSS.n7 30.0871
R35 VSS.n26 VSS.t6 30.0865
R36 VSS.t0 VSS.n26 30.0871
R37 VSS.n28 VSS.t0 23.8211
R38 VSS.t7 VSS.n27 23.8211
R39 VSS.n13 VSS.t7 30.0865
R40 VSS.t39 VSS.n13 30.0871
R41 VSS.t38 VSS.n8 30.0865
R42 VSS.n24 VSS.t38 30.0865
R43 VSS.t21 VSS.n24 30.0871
R44 VSS.n30 VSS.t12 18.2163
R45 VSS.n10 VSS.t15 24.4816
R46 VSS VSS.n21 1.11904
R47 VSS VSS.n1 1.11904
R48 VSS VSS.n10 1.11904
R49 VSS VSS.n6 1.11904
R50 VSS VSS.n17 1.11904
R51 VSS VSS.n2 1.11904
R52 VSS VSS.n20 1.11904
R53 VSS VSS.n9 1.11904
R54 VSS VSS.n16 1.11904
R55 VSS VSS.n8 1.11904
R56 VSS VSS.n28 8.5004
R57 VSS VSS.n7 1.11904
R58 VSS VSS.n22 1.11904
R59 VSS VSS.n14 1.11904
R60 VSS.n27 VSS 8.50062
R61 VSS.t15 VSS.t36 16.8151
R62 VSS.t23 VSS.n18 18.8774
R63 VSS.t9 VSS.n3 18.8774
R64 VSS.t19 VSS.n16 18.8774
R65 VSS.t26 VSS.n12 18.8774
R66 VSS.t28 VSS.n9 18.8768
R67 VSS.t27 VSS.n20 18.8774
R68 VSS.t25 VSS.n15 18.8774
R69 VSS.t30 VSS.n25 18.8774
R70 VSS.t35 VSS.n2 18.8774
R71 VSS.t24 VSS.n17 18.8768
R72 VSS.t32 VSS.n6 18.8774
R73 VSS.t36 VSS.n11 18.8774
R74 VSS.t31 VSS.n10 18.8774
R75 VSS.t34 VSS.n1 18.8774
R76 VSS.t33 VSS.n21 18.8768
R77 VSS.t29 VSS.n23 18.8774
R78 VSS.t37 VSS.n0 12.1056
R79 VSS.t20 VSS 8.5148
R80 VSS.t5 VSS.n22 30.0871
R81 VSS.t39 VSS.n8 30.0871
R82 VSS.t14 VSS.n9 16.075
R83 VSS.t35 VSS.n17 41.2968
R84 VSS.t34 VSS.n21 41.2968
R85 VSS.n28 VSS.t13 9.809
R86 VSS.n29 VSS 8.501
R87 VSS.n30 VSS 8.5005
R88 VSS.n23 VSS 1.11904
R89 VSS.n11 VSS 1.11904
R90 VSS.n25 VSS 1.11904
R91 VSS.n15 VSS 1.11904
R92 VSS.n12 VSS 1.11904
R93 VSS.n3 VSS 1.11904
R94 VSS.n18 VSS 1.11904
R95 VSS.n24 VSS 1.11904
R96 VSS.n13 VSS 1.11904
R97 VSS.n26 VSS 1.11904
R98 VSS.n4 VSS 1.11904
R99 VSS.n19 VSS 1.11904
R100 VSS.n5 VSS 1.11904
R101 VSS.n31 VSS 1.11895
R102 VSS.t11 VSS 32.3517
R103 VSS VSS.n0 1.27779
C0 a_2212_1750# a_2848_1816# 0.02534f
C1 a_4208_3816# a_3936_3816# 0.08681f
C2 a_5840_3816# a_5976_1816# 0.02083f
C3 VDD a_354_1888# 8.36579f
C4 a_6520_1746# a_242_188# 0.04393f
C5 a_5704_1746# a_5840_1816# 0.02083f
C6 a_4616_1746# a_4616_1816# 0.02083f
C7 a_4072_1816# a_3936_3816# 0.02083f
C8 a_4072_1746# a_4072_1816# 0.02083f
C9 a_2984_1816# a_354_1888# 0.01555f
C10 a_5160_1816# a_5160_1746# 0.02083f
C11 a_242_188# a_5976_1746# 0.03884f
C12 a_4480_1816# a_4616_1816# 1.0062f
C13 a_1776_4026# VDD 0.02111f
C14 a_2984_1816# a_2984_1746# 0.02083f
C15 a_5160_1746# a_5296_1816# 0.02083f
C16 a_3256_1746# a_3528_1746# 0.08681f
C17 a_3120_1816# a_354_1888# 0.01568f
C18 a_4208_1816# a_4208_3816# 0.02083f
C19 a_2984_1746# a_3120_1816# 0.02083f
C20 a_2848_3816# a_2848_1816# 0.02083f
C21 a_4208_1816# a_4072_1816# 1.0062f
C22 a_5432_1816# a_5296_1816# 1.0062f
C23 a_3256_1746# a_3392_1816# 0.02083f
C24 a_2662_224# a_242_188# 7.35937f
C25 a_3392_3816# a_3664_3816# 0.08681f
C26 a_5160_1816# a_5024_1816# 1.0062f
C27 a_3528_1816# a_3392_3816# 0.02083f
C28 a_6112_3816# a_5840_3816# 0.08681f
C29 a_6384_3816# a_6384_1816# 0.02083f
C30 a_5704_1746# a_5432_1746# 0.08681f
C31 a_5568_3816# a_5704_1816# 0.02083f
C32 a_2212_1836# a_242_188# 0.03103f
C33 a_3664_1816# a_3800_1816# 1.0062f
C34 a_2984_1746# a_3256_1746# 0.08681f
C35 a_3256_1816# a_3120_1816# 1.0062f
C36 a_2848_3816# a_2984_1816# 0.02083f
C37 a_1776_1836# a_2212_1836# 1.10179f
C38 a_4344_1816# a_4344_1746# 0.02083f
C39 a_5160_1746# a_4888_1746# 0.08681f
C40 a_6928_3816# a_6656_3816# 0.08681f
C41 a_1776_1836# a_242_188# 0.03162f
C42 a_5432_1746# a_5568_1816# 0.02083f
C43 a_4480_1816# a_4480_3816# 0.02083f
C44 a_5704_1746# a_5976_1746# 0.08681f
C45 a_5432_1816# a_5568_1816# 1.0062f
C46 a_242_188# a_4616_1746# 0.02909f
C47 a_5704_1746# a_5704_1816# 0.02083f
C48 a_2848_1816# a_2212_1836# 0.35347f
C49 a_3256_1816# a_3256_1746# 0.02083f
C50 a_3664_3816# a_3936_3816# 0.08681f
C51 a_5024_3816# a_5160_1816# 0.02083f
C52 a_4616_1816# a_4752_1816# 1.0062f
C53 a_7064_1816# a_2662_224# 0.04433f
C54 a_6248_1746# a_6248_1816# 0.02083f
C55 a_3800_1746# a_3800_1816# 0.02083f
C56 a_4888_1746# a_5024_1816# 0.02083f
C57 a_3392_3816# a_3120_3816# 0.08681f
C58 a_6248_1746# a_6384_1816# 0.02083f
C59 a_4752_3816# a_4752_1816# 0.02083f
C60 a_4344_1816# a_4208_1816# 1.0062f
C61 a_3936_1816# a_3800_1816# 1.0062f
C62 a_6112_3816# a_6384_3816# 0.08681f
C63 a_5704_1816# a_5568_1816# 1.0062f
C64 a_6656_1816# a_6520_1816# 1.0062f
C65 a_6520_1816# a_6384_1816# 1.0062f
C66 a_3800_1746# a_242_188# 0.03688f
C67 a_242_188# iout 0.42629f
C68 VDD a_2212_1836# 0.02348f
C69 a_4344_1816# a_4208_3816# 0.02083f
C70 a_6928_1816# a_6792_1816# 1.0062f
C71 a_3120_3816# a_3120_1816# 0.02083f
C72 a_3392_1816# a_354_1888# 0.016f
C73 VDD a_242_188# 1.68791f
C74 a_5568_3816# a_5840_3816# 0.08681f
C75 a_5704_1746# a_242_188# 0.02686f
C76 a_7064_1816# a_6928_3816# 0.02083f
C77 a_6112_1816# a_6248_1816# 1.0062f
C78 a_1776_1836# VDD 0.26474f
C79 a_4888_1816# a_4888_1746# 0.02083f
C80 a_4888_1816# a_4752_1816# 1.0062f
C81 a_6520_1746# a_6248_1746# 0.08681f
C82 a_5160_1816# a_5296_1816# 1.0062f
C83 a_6248_1746# a_5976_1746# 0.08681f
C84 a_6656_1816# a_6792_1816# 1.0062f
C85 a_3528_1816# a_3528_1746# 0.02083f
C86 a_6384_3816# a_6656_3816# 0.08681f
C87 a_5976_1816# a_6112_1816# 1.0062f
C88 a_6520_1816# a_6520_1746# 0.02083f
C89 a_3256_1816# a_3392_1816# 1.0062f
C90 a_5296_3816# a_5432_1816# 0.02083f
C91 a_4344_1746# a_242_188# 0.04393f
C92 a_3528_1816# a_3392_1816# 1.0062f
C93 a_242_188# a_4888_1746# 0.03832f
C94 a_2212_1750# a_354_1888# 0.01852f
C95 a_2984_1816# a_2848_1816# 1.0062f
C96 a_3800_1746# a_3936_1816# 0.02083f
C97 a_2212_1750# a_2984_1746# 0.08772f
C98 a_6384_1816# a_6248_1816# 1.0062f
C99 a_5840_1816# a_5976_1816# 1.0062f
C100 a_6792_1746# a_6928_1816# 0.02083f
C101 a_3256_1746# a_242_188# 0.04393f
C102 a_4072_1746# a_242_188# 0.04393f
C103 a_6792_1746# a_6792_1816# 0.02083f
C104 a_4344_1746# a_4616_1746# 0.08681f
C105 a_3256_1816# a_354_1888# 0.01583f
C106 a_4616_1746# a_4888_1746# 0.08681f
C107 a_4480_1816# a_4344_1746# 0.02083f
C108 a_3528_1816# a_354_1888# 0.01614f
C109 a_4616_1746# a_4752_1816# 0.02083f
C110 a_5976_1746# a_6112_1816# 0.02083f
C111 a_5568_3816# a_5568_1816# 0.02083f
C112 a_6112_3816# a_6112_1816# 0.02083f
C113 a_4480_3816# a_4208_3816# 0.08681f
C114 a_242_188# a_6248_1746# 0.04393f
C115 a_2984_1816# a_3120_1816# 1.0062f
C116 a_5704_1816# a_5840_1816# 1.0062f
C117 a_5432_1746# a_5160_1746# 0.08681f
C118 a_6656_1816# a_6520_1746# 0.02083f
C119 a_4072_1746# a_3800_1746# 0.08681f
C120 a_5296_3816# a_5024_3816# 0.08681f
C121 a_6112_3816# a_6248_1816# 0.02083f
C122 a_5432_1746# a_5432_1816# 0.02083f
C123 a_3936_3816# a_3936_1816# 0.02083f
C124 a_2662_224# a_354_1888# 2.2693f
C125 a_3528_1746# a_242_188# 0.03137f
C126 a_3528_1746# a_3664_1816# 0.02083f
C127 a_5976_1746# a_5976_1816# 0.02083f
C128 a_6792_1746# a_6520_1746# 0.08681f
C129 a_6792_1816# a_6656_3816# 0.02083f
C130 a_2212_1836# a_354_1888# 0.08782f
C131 a_1776_4026# a_2212_1836# 0.08019f
C132 a_6928_3816# a_6928_1816# 0.02083f
C133 a_242_188# a_354_1888# 3.27191f
C134 a_4072_1746# a_4344_1746# 0.08681f
C135 a_2984_1746# a_242_188# 0.04393f
C136 a_354_1888# a_3664_1816# 0.01634f
C137 a_5568_3816# a_5296_3816# 0.08681f
C138 a_1776_1836# a_354_1888# 0.13335f
C139 a_2212_1750# a_2212_1836# 0.08019f
C140 a_6792_1746# a_2662_224# 0.10266f
C141 a_4072_1816# a_3936_1816# 1.0062f
C142 a_6656_1816# a_6656_3816# 0.02083f
C143 a_3256_1816# a_3120_3816# 0.02083f
C144 a_5296_3816# a_5296_1816# 0.02083f
C145 a_1776_4026# a_1776_1836# 0.08019f
C146 a_3800_1746# a_3528_1746# 0.08681f
C147 a_3664_3816# a_3800_1816# 0.02083f
C148 a_2212_1750# a_242_188# 0.06538f
C149 a_5840_1816# a_5840_3816# 0.02083f
C150 a_2848_3816# a_3120_3816# 0.08681f
C151 a_5160_1746# a_242_188# 0.04393f
C152 a_4752_3816# a_4888_1816# 0.02083f
C153 a_4888_1816# a_5024_1816# 1.0062f
C154 a_2848_1816# a_354_1888# 0.01706f
C155 a_3392_3816# a_3392_1816# 0.02083f
C156 a_4480_3816# a_4616_1816# 0.02083f
C157 a_2848_3816# a_2212_1836# 0.01487f
C158 a_5024_3816# a_4752_3816# 0.08681f
C159 a_4072_1746# a_4208_1816# 0.02083f
C160 a_3664_3816# a_3664_1816# 0.02083f
C161 a_5432_1746# a_242_188# 0.04393f
C162 a_5024_3816# a_5024_1816# 0.02083f
C163 a_6520_1816# a_6384_3816# 0.02083f
C164 a_6792_1746# a_242_188# 0.02021f
C165 a_4480_3816# a_4752_3816# 0.08681f
C166 a_7064_1816# a_6928_1816# 1.0062f
C167 a_3528_1816# a_3664_1816# 1.0062f
C168 a_4480_1816# a_4344_1816# 1.0062f
C169 iout VSS 0.98178f
C170 VDD VSS 11.91164f
C171 a_2662_224# VSS 21.82635f
C172 a_6928_3816# VSS 0.95837f
C173 a_6792_1746# VSS 0.81087f
C174 a_6656_3816# VSS 0.75699f
C175 a_6520_1746# VSS 0.80431f
C176 a_6384_3816# VSS 0.75699f
C177 a_6248_1746# VSS 0.80431f
C178 a_6112_3816# VSS 0.75699f
C179 a_5976_1746# VSS 0.80585f
C180 a_5840_3816# VSS 0.75699f
C181 a_5704_1746# VSS 0.81005f
C182 a_5568_3816# VSS 0.75699f
C183 a_5432_1746# VSS 0.80431f
C184 a_5296_3816# VSS 0.75699f
C185 a_5160_1746# VSS 0.80431f
C186 a_5024_3816# VSS 0.75699f
C187 a_4888_1746# VSS 0.80602f
C188 a_4752_3816# VSS 0.75699f
C189 a_4616_1746# VSS 0.80923f
C190 a_4480_3816# VSS 0.75699f
C191 a_4344_1746# VSS 0.80431f
C192 a_4208_3816# VSS 0.75699f
C193 a_4072_1746# VSS 0.80431f
C194 a_3936_3816# VSS 0.75699f
C195 a_3800_1746# VSS 0.80651f
C196 a_3664_3816# VSS 0.75699f
C197 a_3528_1746# VSS 0.80842f
C198 a_3392_3816# VSS 0.75699f
C199 a_3256_1746# VSS 0.80432f
C200 a_3120_3816# VSS 0.75699f
C201 a_2984_1746# VSS 0.80432f
C202 a_2848_3816# VSS 0.88459f
C203 a_2212_1750# VSS 2.33093f
C204 a_1776_4026# VSS 2.97422f
.ends
