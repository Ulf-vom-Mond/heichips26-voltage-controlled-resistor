* PEX produced on Di 15. Sep 13:27:12 CEST 2026 using scripts/sak-pex.sh with m=3 and s=1 (extresist threshold=10000 mOhm, minres=1000 mOhm, mindelay=1 ps)
* NGSPICE file created from hv_nand_pex.ext - technology: ihp-sg13cmos5l

.subckt hv_nand_pex VDD in1 out in2 VSS
X0 a_n362_n876# in2 VSS.t1 VSS.t2 sg13_hv_nmos ad=0.57p pd=3.38u as=0.57p ps=3.38u w=3u l=0.45u
X1 VDD in2 out VDD sg13_hv_pmos ad=3.4p pd=20.68u as=1.9p ps=10.38u w=10u l=0.4u
X2 a_n362_n876# in1 out VSS.t5 sg13_hv_nmos ad=0.57p pd=3.38u as=0.57p ps=3.38u w=3u l=0.45u
X3 VSS.t1 in2 a_n362_n876# VSS.t3 sg13_hv_nmos ad=0.57p pd=3.38u as=0.57p ps=3.38u w=3u l=0.45u
X4 out in1 VDD VDD sg13_hv_pmos ad=1.9p pd=10.38u as=1.9p ps=10.38u w=10u l=0.4u
X5 VDD in1 out VDD sg13_hv_pmos ad=3.4p pd=20.68u as=1.9p ps=10.38u w=10u l=0.4u
X6 a_n362_n876# in1 out VSS.t7 sg13_hv_nmos ad=1.02p pd=6.68u as=0.57p ps=3.38u w=3u l=0.45u
X7 out in2 VDD VDD sg13_hv_pmos ad=1.9p pd=10.38u as=3.4p ps=20.68u w=10u l=0.4u
X8 VSS.t1 in2 a_n362_n876# VSS.t0 sg13_hv_nmos ad=0.57p pd=3.38u as=1.02p ps=6.68u w=3u l=0.45u
X9 out in1 VDD VDD sg13_hv_pmos ad=1.9p pd=10.38u as=3.4p ps=20.68u w=10u l=0.4u
X10 out in1 a_n362_n876# VSS.t6 sg13_hv_nmos ad=0.57p pd=3.38u as=0.57p ps=3.38u w=3u l=0.45u
X11 a_n362_n876# in2 VSS.t1 VSS.t4 sg13_hv_nmos ad=1.02p pd=6.68u as=0.57p ps=3.38u w=3u l=0.45u
X12 out in2 VDD VDD sg13_hv_pmos ad=1.9p pd=10.38u as=1.9p ps=10.38u w=10u l=0.4u
X13 out in1 a_n362_n876# VSS.t1 sg13_hv_nmos ad=0.57p pd=3.38u as=1.02p ps=6.68u w=3u l=0.45u
X14 VDD in2 out VDD sg13_hv_pmos ad=1.9p pd=10.38u as=1.9p ps=10.38u w=10u l=0.4u
X15 VDD in1 out VDD sg13_hv_pmos ad=1.9p pd=10.38u as=1.9p ps=10.38u w=10u l=0.4u
R0 VSS.t1 VSS.t5 29.1282
R1 VSS.t1 VSS.t3 27.0604
R2 VSS.t7 VSS.t1 43.8365
R3 VSS.t1 VSS.t4 43.8369
R4 VSS.t2 VSS.t1 29.1272
R5 VSS.t1 VSS.t6 27.0593
R6 VSS VSS.t1 0.382424
R7 VSS.t1 VSS.t0 43.8372
C0 out in2 2.65778f
C1 in1 VDD 3.52258f
C2 a_n362_n876# out 2.56545f
C3 a_n362_n876# in2 1.22145f
C4 in1 out 3.36823f
C5 in1 in2 0.15995f
C6 in1 a_n362_n876# 1.37135f
C7 VDD out 8.38426f
C8 VDD in2 3.52258f
C9 out VSS 2.14912f
C10 VDD VSS 1.31944f
C11 a_n362_n876# VSS 5.93749f
C12 VSS.t1 VSS 1.21391f
.ends
