* PEX produced on Mi 9. Sep 14:34:35 CEST 2026 using scripts/sak-pex.sh with m=3 and s=1 (extresist threshold=10000 mOhm, minres=1000 mOhm, mindelay=1 ps)
* NGSPICE file created from hv_nand_pex.ext - technology: ihp-sg13cmos5l

.subckt hv_nand_pex VDD in1 out in2 VSS
X0 a_n362_n876# in2 VSS.t1 VSS.t2 sg13_hv_nmos ad=0.57p pd=3.38u as=0.57p ps=3.38u w=3u l=0.45u
X1 VDD in2 out VDD sg13_hv_pmos ad=3.4p pd=20.68u as=1.9p ps=10.38u w=10u l=0.4u
X2 a_n362_n876# in1 out VSS.t7 sg13_hv_nmos ad=0.57p pd=3.38u as=0.57p ps=3.38u w=3u l=0.45u
X3 VSS.t4 in2 a_n362_n876# VSS.t3 sg13_hv_nmos ad=0.57p pd=3.38u as=0.57p ps=3.38u w=3u l=0.45u
X4 out in1 VDD VDD sg13_hv_pmos ad=1.9p pd=10.38u as=1.9p ps=10.38u w=10u l=0.4u
X5 VDD in1 out VDD sg13_hv_pmos ad=3.4p pd=20.68u as=1.9p ps=10.38u w=10u l=0.4u
X6 a_n362_n876# in1 out VSS.t9 sg13_hv_nmos ad=1.02p pd=6.68u as=0.57p ps=3.38u w=3u l=0.45u
X7 out in2 VDD VDD sg13_hv_pmos ad=1.9p pd=10.38u as=3.4p ps=20.68u w=10u l=0.4u
X8 VSS.t1 in2 a_n362_n876# VSS.t0 sg13_hv_nmos ad=0.57p pd=3.38u as=1.02p ps=6.68u w=3u l=0.45u
X9 out in1 VDD VDD sg13_hv_pmos ad=1.9p pd=10.38u as=3.4p ps=20.68u w=10u l=0.4u
X10 out in1 a_n362_n876# VSS.t8 sg13_hv_nmos ad=0.57p pd=3.38u as=0.57p ps=3.38u w=3u l=0.45u
X11 a_n362_n876# in2 VSS.t4 VSS.t5 sg13_hv_nmos ad=1.02p pd=6.68u as=0.57p ps=3.38u w=3u l=0.45u
X12 out in2 VDD VDD sg13_hv_pmos ad=1.9p pd=10.38u as=1.9p ps=10.38u w=10u l=0.4u
X13 out in1 a_n362_n876# VSS.t6 sg13_hv_nmos ad=0.57p pd=3.38u as=1.02p ps=6.68u w=3u l=0.45u
X14 VDD in2 out VDD sg13_hv_pmos ad=1.9p pd=10.38u as=1.9p ps=10.38u w=10u l=0.4u
X15 VDD in1 out VDD sg13_hv_pmos ad=1.9p pd=10.38u as=1.9p ps=10.38u w=10u l=0.4u
R0 VSS.n40 VSS.t7 289.19
R1 VSS.n37 VSS.t2 289.19
R2 VSS.n43 VSS.n25 270.271
R3 VSS.n5 VSS.n25 191.91
R4 VSS.n39 VSS.n11 191.91
R5 VSS.n40 VSS.t8 159.459
R6 VSS.n37 VSS.t3 159.459
R7 VSS.t9 VSS.n7 135.167
R8 VSS.n5 VSS.t0 135.154
R9 VSS.n11 VSS.t6 135.153
R10 VSS.n9 VSS.t9 64.8832
R11 VSS.n2 VSS.t5 64.8832
R12 VSS.t6 VSS.n10 64.883
R13 VSS.t0 VSS.n1 64.8827
R14 VSS.t7 VSS.n10 32.4508
R15 VSS.t8 VSS.n9 32.4505
R16 VSS.t3 VSS.n2 32.4505
R17 VSS.t2 VSS.n1 32.4501
R18 VSS.n43 VSS.n7 15.6184
R19 VSS.n15 VSS.n13 0.00139773
R20 VSS.n24 VSS.n13 0.00158329
R21 VSS.n39 VSS.n24 2.83428
R22 VSS.n16 VSS.n22 0.00388861
R23 VSS.n21 VSS.n6 5.61358
R24 VSS.n15 VSS.n30 4.68218
R25 VSS.n34 VSS.n14 0.197604
R26 VSS.n17 VSS.n18 3.32867
R27 VSS.n13 VSS.n40 8.5005
R28 VSS.n13 VSS.n37 8.5005
R29 VSS.n23 VSS.n8 1.43762
R30 VSS.n23 VSS.n22 2.28452
R31 VSS.n0 VSS.n36 8.46995
R32 VSS.n27 VSS.n3 3.30427
R33 VSS.n20 VSS.n21 0.530945
R34 VSS.n13 VSS.n35 8.45904
R35 VSS.n16 VSS.n12 0.00211081
R36 VSS.n43 VSS.n6 2.43059
R37 VSS.n30 VSS.n31 0.00316617
R38 VSS.n17 VSS.n25 1.54663
R39 VSS.n19 VSS.n43 2.43044
R40 VSS.n13 VSS.n20 3.29663
R41 VSS.n31 VSS.n26 5.61281
R42 VSS.n16 VSS.n39 1.88972
R43 VSS.n3 VSS.n25 4.25213
R44 VSS.n38 VSS.n12 4.20262
R45 VSS.n13 VSS.n42 3.36789
R46 VSS.n13 VSS.n14 1.82959
R47 VSS.n13 VSS.n33 3.36089
R48 VSS.t4 VSS.n32 2.47686
R49 VSS.t1 VSS.n32 2.23739
R50 VSS.n27 VSS.n4 1.30523
R51 VSS.n13 VSS.n29 1.03093
R52 VSS.n8 VSS.n21 1.1859
R53 VSS.n13 VSS.n8 0.540339
R54 VSS.n41 VSS.t1 0.664532
R55 VSS.n34 VSS.t4 0.664532
R56 VSS.n13 VSS.n4 0.540429
R57 VSS.n38 VSS.n29 0.387403
R58 VSS.n36 VSS.n26 0.356698
R59 VSS.n23 VSS.n38 0.664861
R60 VSS.n18 VSS.n35 0.423953
R61 VSS.n4 VSS.n26 1.1891
R62 VSS.n27 VSS.n35 0.456192
R63 VSS.n44 VSS.n29 0.296325
R64 VSS.n46 VSS.n32 0.277484
R65 VSS.n44 VSS.n20 0.358597
R66 VSS.n18 VSS.n28 0.135707
R67 VSS.n46 VSS.n45 0.173577
R68 VSS.n36 VSS.n14 0.424631
R69 VSS.n42 VSS.n41 0.12494
R70 VSS.n41 VSS.n33 0.106631
R71 VSS.n34 VSS.n33 0.101985
R72 VSS.n42 VSS.n28 0.0854124
R73 VSS.n45 VSS.n28 0.0367813
R74 VSS.n45 VSS.n44 0.0367813
R75 VSS VSS.n46 0.0293525
R76 VSS.n13 VSS.n1 0.0165363
R77 VSS.n13 VSS.n11 0.0165363
R78 VSS.n13 VSS.n2 0.0162868
R79 VSS.n13 VSS.n9 0.0162868
R80 VSS.n13 VSS.n10 0.0162868
R81 VSS.n13 VSS.n5 0.0162868
R82 VSS.n13 VSS.n7 0.00224606
R83 VSS.n13 VSS.n6 0.00154544
R84 VSS.n30 VSS.n0 0.00333242
R85 VSS.n31 VSS.n13 0.00329996
R86 VSS.n24 VSS.n22 0.00316647
R87 VSS.n13 VSS.n3 0.00307142
R88 VSS.n19 VSS.n44 8.5018
R89 VSS.n13 VSS.n17 0.0031134
R90 VSS.n13 VSS.n0 0.00299997
R91 VSS.n19 VSS.n13 0.00293404
R92 VSS.n13 VSS.n12 0.00249999
R93 VSS.n15 VSS.t5 135.171
C0 in2 VDD 3.89417f
C1 a_n362_n876# in1 1.36749f
C2 out a_n362_n876# 2.43403f
C3 in2 a_n362_n876# 1.38297f
C4 a_n362_n876# VDD 0.01525f
C5 out in1 3.28474f
C6 in2 in1 0.15995f
C7 VDD in1 3.89417f
C8 in2 out 2.58464f
C9 out VDD 15.9135f
C10 out VSS 1.92402f
C11 VDD VSS 1.5371f
C12 a_n362_n876# VSS 7.41515f
C13 VSS.t1 VSS 1.26474f
.ends
