* PEM produced on Do 10. Sep 10:15:02 CEST 2026 using scripts/sak-pex.sh with m=3 and s=1 (extresist threshold=10000 mOhm, minres=1000 mOhm, mindelay=1 ps)
* NGSPICE file created from comp_nmos_pex.ext - technology: ihp-sg13cmos5l

.subckt comp_nmos_pex out - + VDD Ibias VSS
M0 VDD a_n406_62# a_n406_62# VDD sg13_hv_pmos ad=0.38p pd=2.38u as=0.68p ps=4.68u w=2u l=0.4u
M1 a_118_854# a_n406_62# VDD VDD sg13_hv_pmos ad=0.68p pd=4.68u as=0.38p ps=2.38u w=2u l=0.4u
M2 VSS.t1 Ibias Ibias VSS.t0 sg13_hv_nmos ad=0.408p pd=3.08u as=0.408p ps=3.08u w=1.2u l=1.5u
M3 out Ibias VSS.t3 VSS.t4 sg13_hv_nmos ad=0.816p pd=5.48u as=0.456p ps=2.78u w=2.4u l=1.5u
M4 a_n38_62# - a_n406_62# VSS.t5 sg13_hv_nmos ad=0.228p pd=1.58u as=0.408p ps=3.08u w=1.2u l=1.5u
M5 VSS.t3 Ibias a_n38_62# VSS.t2 sg13_hv_nmos ad=0.456p pd=2.78u as=0.816p ps=5.48u w=2.4u l=1.5u
M6 VDD a_118_854# out VDD sg13_hv_pmos ad=0.68p pd=4.68u as=0.68p ps=4.68u w=2u l=0.4u
M7 a_118_854# + a_n38_62# VSS.t2 sg13_hv_nmos ad=0.408p pd=3.08u as=0.228p ps=1.58u w=1.2u l=1.5u
R0 VSS.n50 VSS.n38 129.845
R1 VSS.t0 VSS.n15 86.022
R2 VSS.n64 VSS.n6 72.3873
R3 VSS.n58 VSS.n1 71.9773
R4 VSS.n74 VSS.n73 70.401
R5 VSS.n33 VSS.n21 70.401
R6 VSS.n27 VSS.n15 70.401
R7 VSS.n35 VSS.n17 70.4009
R8 VSS.n44 VSS.n1 64.8081
R9 VSS.n46 VSS.n9 64.5166
R10 VSS.n44 VSS.n13 64.5166
R11 VSS.n2 VSS.n59 64.5166
R12 VSS.n61 VSS.n14 64.5166
R13 VSS.n65 VSS.n18 64.5166
R14 VSS.n34 VSS.n16 64.5166
R15 VSS.n46 VSS.n8 57.3482
R16 VSS.n58 VSS.n9 57.3482
R17 VSS.n59 VSS.n13 57.3482
R18 VSS.n61 VSS.n7 57.3482
R19 VSS.n34 VSS.n33 57.3482
R20 VSS.n20 VSS.t4 37.1253
R21 VSS.n38 VSS.t5 36.6547
R22 VSS.n72 VSS.t0 36.6543
R23 VSS.t5 VSS.n8 35.8428
R24 VSS.n60 VSS.t2 34.7669
R25 VSS.t2 VSS.n2 28.6743
R26 VSS.t4 VSS.n19 28.6743
R27 VSS.n5 VSS.n74 17.0005
R28 VSS.n5 VSS.n6 17.0005
R29 VSS.n5 VSS.n14 17.0005
R30 VSS.n5 VSS.n7 17.0005
R31 VSS.n5 VSS.n12 17.0005
R32 VSS.n5 VSS.n10 17.0005
R33 VSS.n72 VSS.n45 17.0005
R34 VSS.n72 VSS.n57 17.0005
R35 VSS.n72 VSS.n47 17.0005
R36 VSS.n69 VSS.n68 17.0005
R37 VSS.n72 VSS.n22 17.0005
R38 VSS.n72 VSS.n23 17.0005
R39 VSS.t1 VSS.n40 17.0005
R40 VSS.t1 VSS.n39 17.0005
R41 VSS.n41 VSS.t1 17.0005
R42 VSS.n5 VSS.n16 17.0005
R43 VSS.n5 VSS.n17 17.0005
R44 VSS.n5 VSS.n18 17.0005
R45 VSS.n5 VSS.n19 17.0005
R46 VSS.n64 VSS.n14 13.384
R47 VSS.n74 VSS.n20 12.8207
R48 VSS.n60 VSS.n7 12.1852
R49 VSS.n21 VSS.n17 11.7692
R50 VSS.n73 VSS.n6 11.7692
R51 VSS.n27 VSS.n16 11.7692
R52 VSS.n35 VSS.n18 11.7685
R53 VSS.n65 VSS.n28 10.6735
R54 VSS.n28 VSS.n19 10.6735
R55 VSS.n33 VSS.n5 8.501
R56 VSS.n5 VSS.n13 8.5005
R57 VSS.n5 VSS.n9 8.5005
R58 VSS.n72 VSS.n61 8.5005
R59 VSS.n72 VSS.n59 8.5005
R60 VSS.n72 VSS.n44 8.5005
R61 VSS.n72 VSS.n58 8.5005
R62 VSS.n72 VSS.n46 8.5005
R63 VSS.n72 VSS.n34 8.5005
R64 VSS.n5 VSS.n11 8.48642
R65 VSS.n70 VSS.n69 8.48642
R66 VSS.n72 VSS.n30 8.48642
R67 VSS.n54 VSS.n49 8.46995
R68 VSS.n65 VSS.n32 5.66778
R69 VSS.n51 VSS.n50 5.66778
R70 VSS.n50 VSS.n48 5.66778
R71 VSS.n72 VSS.n71 5.65482
R72 VSS.n53 VSS.n52 5.61121
R73 VSS.n50 VSS.n36 4.251
R74 VSS.n75 VSS.n5 4.2505
R75 VSS.n72 VSS.n29 3.37765
R76 VSS.n72 VSS.n28 3.16474
R77 VSS.n66 VSS.n65 2.8348
R78 VSS.n72 VSS.n56 2.42009
R79 VSS.n72 VSS.n63 2.39622
R80 VSS.n72 VSS.n31 1.84671
R81 VSS.n72 VSS.n24 1.84232
R82 VSS.n72 VSS.n21 1.74538
R83 VSS.n72 VSS.n27 1.74538
R84 VSS.n73 VSS.n72 1.74538
R85 VSS.n72 VSS.n35 1.74516
R86 VSS.n72 VSS.n26 1.65363
R87 VSS.n72 VSS.n60 1.60627
R88 VSS.n5 VSS.n15 1.30819
R89 VSS.n5 VSS.n8 1.30819
R90 VSS.n53 VSS.n37 1.09113
R91 VSS.n72 VSS.n43 1.0437
R92 VSS.n42 VSS.n37 0.960776
R93 VSS.n5 VSS.n4 0.886426
R94 VSS.n5 VSS.n0 0.883526
R95 VSS.n62 VSS.t3 0.797094
R96 VSS.n72 VSS.n37 0.705183
R97 VSS.n43 VSS.n42 0.588356
R98 VSS.n5 VSS.n1 0.521543
R99 VSS.n72 VSS.n20 0.381025
R100 VSS.n43 VSS.n41 0.357039
R101 VSS.n54 VSS.n53 0.31752
R102 VSS.n0 VSS.t3 0.269173
R103 VSS.n4 VSS.t3 0.263413
R104 VSS.n56 VSS.n54 0.255072
R105 VSS.n40 VSS.n24 0.245527
R106 VSS.n55 VSS.n0 0.175132
R107 VSS.n25 VSS.n4 0.169438
R108 VSS.n68 VSS.n31 0.168787
R109 VSS.n26 VSS.n25 0.137836
R110 VSS.n67 VSS.n26 0.136039
R111 VSS.n42 VSS.n31 0.132618
R112 VSS.n63 VSS.n62 0.120634
R113 VSS.n63 VSS.n12 0.118665
R114 VSS.n72 VSS.n64 0.108523
R115 VSS.n67 VSS.n29 0.0892103
R116 VSS.n62 VSS.n29 0.0888642
R117 VSS.n25 VSS.n24 0.0738022
R118 VSS.n71 VSS.n70 0.0702044
R119 VSS.n57 VSS.n11 0.0611061
R120 VSS.n70 VSS.n30 0.0598372
R121 VSS.n45 VSS.n11 0.0576686
R122 VSS.n71 VSS.n67 0.0534232
R123 VSS.n47 VSS.n10 0.0314375
R124 VSS.n45 VSS.n12 0.0314375
R125 VSS.n68 VSS.n30 0.0301686
R126 VSS.n40 VSS.n23 0.028257
R127 VSS.n41 VSS.n22 0.028257
R128 VSS.n57 VSS.n10 0.028
R129 VSS.n75 VSS.t3 0.0214
R130 VSS.n56 VSS.n55 0.0207105
R131 VSS.n39 VSS.n23 0.0190047
R132 VSS.n39 VSS.n22 0.0190047
R133 VSS VSS.n75 0.0115
R134 VSS.n55 VSS.n47 0.00221875
R135 VSS.n69 VSS.n66 0.0018333
R136 VSS.n52 VSS.n36 0.00175
R137 VSS.n49 VSS.n48 0.00166667
R138 VSS.n51 VSS.n49 0.00166667
R139 VSS.n72 VSS.n32 0.00166667
R140 VSS.n5 VSS.n3 0.00125
R141 VSS.n69 VSS.n32 0.00133332
R142 VSS.n72 VSS.n48 0.00133332
R143 VSS.n52 VSS.n51 0.00133332
R144 VSS.n72 VSS.n36 0.00124998
R145 VSS.n72 VSS.n66 0.00116668
R146 VSS.n72 VSS.n38 0.00112291
R147 VSS.n72 VSS.n3 0.001125
R148 VSS.n3 VSS.n2 8.50175
C0 + - 0.21528f
C1 + Ibias 0.24552f
C2 a_n38_62# a_118_854# 0.05227f
C3 out a_118_854# 1.06618f
C4 a_n406_62# a_n38_62# 0.05466f
C5 out a_n406_62# 0.01551f
C6 a_n38_62# - 0.4665f
C7 a_n38_62# Ibias 0.57524f
C8 out Ibias 0.80742f
C9 VDD a_118_854# 2.96604f
C10 VDD a_n406_62# 2.39328f
C11 VDD - 0.04374f
C12 + a_n38_62# 0.46614f
C13 VDD Ibias 0.04202f
C14 + out 0.02106f
C15 a_n406_62# a_118_854# 0.18593f
C16 Ibias a_118_854# 0.17681f
C17 + VDD 0.0467f
C18 a_n406_62# - 0.69814f
C19 out a_n38_62# 0.17218f
C20 - Ibias 0.01127f
C21 + a_118_854# 0.67026f
C22 VDD a_n38_62# 0.0105f
C23 + a_n406_62# 0.01638f
C24 VDD out 0.60265f
C25 out VSS 1.6924f
C26 VDD VSS 1.80661f
C27 a_n38_62# VSS 2.2421f
C28 a_118_854# VSS 0.49394f
C29 a_n406_62# VSS 0.5607f
C30 VSS.t1 VSS 2.58992f
.ends
