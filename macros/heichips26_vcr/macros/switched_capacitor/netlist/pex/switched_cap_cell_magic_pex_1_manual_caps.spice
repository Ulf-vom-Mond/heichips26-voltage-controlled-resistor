* PEX produced on Fr 18. Sep 10:42:04 CEST 2026 using scripts/sak-pex.sh with m=1 and s=1
* NGSPICE file created from switched_cap_cell_pex.ext - technology: ihp-sg13cmos5l

.subckt switched_cap_cell_pex ctrl VAPWR VGND r2 r1 clkin selA selB en VPWR
+ clkout
X0 VAPWR transmission_gate_2.vout osc_0.c1 VAPWR sg13_hv_pmos ad=0.19p pd=1.38u as=0.34p ps=2.68u w=1u l=2u
X1 a_11754_8302# hv_mux4_0.hv_nor4_0.in2 a_12854_8302# VAPWR sg13_hv_pmos ad=1.9p pd=10.38u as=1.9p ps=10.38u w=10u l=0.4u
X2 transmission_gate_0.vout transmission_gate_0.nvctrl r2 VAPWR sg13_hv_pmos ad=0.95p pd=5.38u as=0.95p ps=5.38u w=5u l=0.45u
X3 a_36_1840# a_242_282# a_1242_318# VGND sg13_hv_nmos ad=2.04p pd=12.68u as=1.14p ps=6.38u w=6u l=5u
X4 a_13934_11830# pulse_shaper_en_0.en VGND VGND sg13_hv_nmos ad=1.02p pd=6.68u as=0.57p ps=3.38u w=3u l=0.45u
X5 VAPWR a_10394_5544# VGND rhigh l=11.3u w=0.5u
X6 VGND hv_mux4_0.nsel3 hv_mux4_0.hv_nor_2.out VGND sg13_hv_nmos ad=0.57p pd=3.38u as=0.57p ps=3.38u w=3u l=0.45u
X7 VGND hv_mux4_0.hv_nor4_0.in2 hv_inverter_40u_0.in VGND sg13_hv_nmos ad=1.02p pd=6.68u as=0.57p ps=3.38u w=3u l=0.45u
X8 hv_mux4_0.in1 lvl_shift_up_0.hv_inverter_6u5_0.in VGND VGND sg13_hv_nmos ad=0.68p pd=4.68u as=0.68p ps=4.68u w=2u l=0.45u
X9 VAPWR hv_binary_decoder4_0.hv_nand_0.in2 hv_mux4_0.nsel1 VAPWR sg13_hv_pmos ad=3.4p pd=20.68u as=1.9p ps=10.38u w=10u l=0.4u
X10 transmission_gate_0.vout transmission_gate_0.vctrl r2 VGND sg13_hv_nmos ad=0.38p pd=2.38u as=0.68p ps=4.68u w=2u l=0.45u
X11 transmission_gate_1.nvctrl transmission_gate_1.vctrl VAPWR VAPWR sg13_hv_pmos ad=1.9p pd=10.38u as=3.4p ps=20.68u w=10u l=0.4u
X12 transmission_gate_0.vout transmission_gate_1.nvctrl r1 VAPWR sg13_hv_pmos ad=0.95p pd=5.38u as=1.7p ps=10.68u w=5u l=0.45u
X13 ctrl hv_inverter_40u_1.out transmission_gate_2.vout VGND sg13_hv_nmos ad=0.38p pd=2.38u as=0.38p ps=2.38u w=2u l=0.45u
X14 VAPWR transmission_gate_2.vout hv_mux4_0.in3 VAPWR sg13_hv_pmos ad=3.4p pd=20.68u as=3.4p ps=20.68u w=10u l=2u
X15 VAPWR transmission_gate_2.vout transmission_gate_2.vout VAPWR sg13_hv_pmos ad=1.9p pd=10.38u as=3.4p ps=20.68u w=10u l=2u
X16 hv_mux4_0.nsel2 hv_binary_decoder4_0.hv_nand_0.in1 a_2934_11830# VGND sg13_hv_nmos ad=0.57p pd=3.38u as=1.02p ps=6.68u w=3u l=0.45u
X17 hv_mux4_0.nsel3 hv_binary_decoder4_0.msb VAPWR VAPWR sg13_hv_pmos ad=1.9p pd=10.38u as=1.9p ps=10.38u w=10u l=0.4u
X18 hv_mux4_0.nsel3 hv_binary_decoder4_0.hv_nand_0.in2 VAPWR VAPWR sg13_hv_pmos ad=1.9p pd=10.38u as=3.4p ps=20.68u w=10u l=0.4u
X19 a_9928_282# a_9928_282# VGND VGND sg13_hv_nmos ad=1.14p pd=6.38u as=1.14p ps=6.38u w=6u l=5u
X20 VAPWR vco_0.nout hv_mux4_0.in2 VAPWR sg13_hv_pmos ad=3.4p pd=20.68u as=1.9p ps=10.38u w=10u l=0.4u
X21 a_4364_4622# vco_0.nout VGND VGND sg13_hv_nmos ad=0.57p pd=3.38u as=0.57p ps=3.38u w=3u l=0.45u
X22 r2 transmission_gate_0.vctrl transmission_gate_0.vout VGND sg13_hv_nmos ad=0.68p pd=4.68u as=0.38p ps=2.38u w=2u l=0.45u
X23 hv_binary_decoder4_0.hv_nand_0.in2 hv_binary_decoder4_0.lsb VGND VGND sg13_hv_nmos ad=0.57p pd=3.38u as=1.02p ps=6.68u w=3u l=0.45u
X24 VAPWR vco_0.hv_rs-ff_0.nS hv_mux4_0.in2 VAPWR sg13_hv_pmos ad=3.4p pd=20.68u as=1.9p ps=10.38u w=10u l=0.4u
X25 a_1124_3910# a_988_1840# VGND rsil l=10u w=0.5u
X26 a_8648_7374# vco_0.comp_pmos_0.+ a_8118_6546# VAPWR sg13_hv_pmos ad=0.38p pd=2.38u as=0.68p ps=4.68u w=2u l=0.4u
X27 VAPWR hv_binary_decoder4_0.msb hv_mux4_0.nsel3 VAPWR sg13_hv_pmos ad=1.9p pd=10.38u as=1.9p ps=10.38u w=10u l=0.4u
X28 a_7372_318# vco_0.bias_current_generator_0.current_reference_40uA_0.iout VAPWR VAPWR sg13_hv_pmos ad=0.95p pd=5.38u as=0.95p ps=5.38u w=5u l=2u
X29 hv_inverter_40u_0.in hv_mux4_0.hv_nor_1.out VGND VGND sg13_hv_nmos ad=0.57p pd=3.38u as=0.57p ps=3.38u w=3u l=0.45u
X30 a_2934_11830# hv_binary_decoder4_0.lsb VGND VGND sg13_hv_nmos ad=1.02p pd=6.68u as=0.57p ps=3.38u w=3u l=0.45u
X31 hv_mux4_0.hv_nor_2.out hv_mux4_0.nsel3 a_7354_8302# VAPWR sg13_hv_pmos ad=1.9p pd=10.38u as=3.4p ps=20.68u w=10u l=0.4u
X32 VAPWR hv_mux4_0.in1 a_2954_8302# VAPWR sg13_hv_pmos ad=1.9p pd=10.38u as=3.4p ps=20.68u w=10u l=0.4u
X33 VGND hv_binary_decoder4_0.lsb hv_binary_decoder4_0.hv_nand_0.in2 VGND sg13_hv_nmos ad=1.02p pd=6.68u as=0.57p ps=3.38u w=3u l=0.45u
X34 transmission_gate_1.nvctrl transmission_gate_1.vctrl VGND VGND sg13_hv_nmos ad=0.57p pd=3.38u as=1.02p ps=6.68u w=3u l=0.45u
X35 hv_inverter_40u_1.out hv_mux4_0.nsel3 VAPWR VAPWR sg13_hv_pmos ad=1.9p pd=10.38u as=3.4p ps=20.68u w=10u l=0.4u
X36 a_14530_2070# a_14530_2070# VGND VGND sg13_hv_nmos ad=2.04p pd=12.68u as=2.04p ps=12.68u w=6u l=5u
X37 a_3028_3910# a_2892_1840# VGND rsil l=10u w=0.5u
X38 a_11754_12982# pulse_shaper_en_0.hv_nor$1_0.in1 transmission_gate_1.vctrl VAPWR sg13_hv_pmos ad=3.4p pd=20.68u as=1.9p ps=10.38u w=10u l=0.4u
X39 a_2756_3910# a_2620_1840# VGND rsil l=10u w=0.5u
X40 VGND hv_binary_decoder4_0.hv_nand_0.in2 a_5134_11830# VGND sg13_hv_nmos ad=0.57p pd=3.38u as=0.57p ps=3.38u w=3u l=0.45u
X41 transmission_gate_0.vout transmission_gate_0.vctrl r2 VGND sg13_hv_nmos ad=0.38p pd=2.38u as=0.38p ps=2.38u w=2u l=0.45u
X42 hv_binary_decoder4_0.hv_nand_0.in1 hv_binary_decoder4_0.msb VAPWR VAPWR sg13_hv_pmos ad=1.9p pd=10.38u as=3.4p ps=20.68u w=10u l=0.4u
X43 transmission_gate_0.nvctrl pulse_shaper_en_0.en VAPWR VAPWR sg13_hv_pmos ad=1.9p pd=10.38u as=1.9p ps=10.38u w=10u l=0.4u
X44 a_10258_7890# vco_0.comp_nmos_0.- VGND rhigh l=11.3u w=0.5u
X45 hv_mux4_0.hv_nor_0.out hv_mux4_0.in1 VGND VGND sg13_hv_nmos ad=0.57p pd=3.38u as=0.57p ps=3.38u w=3u l=0.45u
X46 hv_inverter_40u_0.in hv_mux4_0.hv_nor_0.out VGND VGND sg13_hv_nmos ad=0.57p pd=3.38u as=1.02p ps=6.68u w=3u l=0.45u
X47 VGND transmission_gate_1.vctrl transmission_gate_1.nvctrl VGND sg13_hv_nmos ad=1.02p pd=6.68u as=0.57p ps=3.38u w=3u l=0.45u
X48 VGND a_10052_3986# vco_0.comp_nmos_0.- VGND sg13_hv_nmos ad=1.14p pd=6.38u as=2.04p ps=12.68u w=6u l=5u
X49 vco_0.comp_pmos_0.Ibias a_7372_318# VGND VGND sg13_hv_nmos ad=2.04p pd=12.68u as=1.14p ps=6.38u w=6u l=5u
X50 VGND lvl_shift_up_3.hv_inverter_6u5_0.in hv_binary_decoder4_0.lsb VGND sg13_hv_nmos ad=0.68p pd=4.68u as=0.68p ps=4.68u w=2u l=0.45u
X51 a_734_11830# hv_binary_decoder4_0.hv_nand_0.in1 hv_mux4_0.nsel1 VGND sg13_hv_nmos ad=0.57p pd=3.38u as=0.57p ps=3.38u w=3u l=0.45u
X52 transmission_gate_0.vout transmission_gate_1.vctrl r1 VGND sg13_hv_nmos ad=0.38p pd=2.38u as=0.68p ps=4.68u w=2u l=0.45u
X53 VAPWR pulse_shaper_en_0.en transmission_gate_0.nvctrl VAPWR sg13_hv_pmos ad=1.9p pd=10.38u as=1.9p ps=10.38u w=10u l=0.4u
X54 r2 transmission_gate_0.vctrl transmission_gate_0.vout VGND sg13_hv_nmos ad=0.38p pd=2.38u as=0.38p ps=2.38u w=2u l=0.45u
X55 r1 transmission_gate_1.nvctrl transmission_gate_0.vout VAPWR sg13_hv_pmos ad=0.95p pd=5.38u as=0.95p ps=5.38u w=5u l=0.45u
X56 ctrl hv_inverter_40u_1.out transmission_gate_2.vout VGND sg13_hv_nmos ad=0.38p pd=2.38u as=0.38p ps=2.38u w=2u l=0.45u
X57 clkout hv_inverter_40u_0.in VGND VGND sg13_hv_nmos ad=0.57p pd=3.38u as=0.57p ps=3.38u w=3u l=0.45u
X58 ctrl hv_mux4_0.nsel3 transmission_gate_2.vout VAPWR sg13_hv_pmos ad=0.95p pd=5.38u as=0.95p ps=5.38u w=5u l=0.45u
X59 vco_0.comp_nmos_0.out a_8484_3986# VAPWR VAPWR sg13_hv_pmos ad=0.68p pd=4.68u as=0.68p ps=4.68u w=2u l=0.4u
X60 a_7334_11830# hv_binary_decoder4_0.lsb VGND VGND sg13_hv_nmos ad=0.57p pd=3.38u as=0.57p ps=3.38u w=3u l=0.45u
X61 hv_inverter_40u_1.out hv_mux4_0.nsel3 VGND VGND sg13_hv_nmos ad=0.57p pd=3.38u as=1.02p ps=6.68u w=3u l=0.45u
X62 a_9554_8302# hv_mux4_0.nsel4 hv_mux4_0.hv_nor_1.out VAPWR sg13_hv_pmos ad=1.9p pd=10.38u as=1.9p ps=10.38u w=10u l=0.4u
X63 transmission_gate_0.vout transmission_gate_1.nvctrl r1 VAPWR sg13_hv_pmos ad=0.95p pd=5.38u as=0.95p ps=5.38u w=5u l=0.45u
X64 a_5154_8302# hv_mux4_0.in2 VAPWR VAPWR sg13_hv_pmos ad=1.9p pd=10.38u as=1.9p ps=10.38u w=10u l=0.4u
X65 a_13934_11830# pulse_shaper_en_0.hv_nand$1_0.in1 transmission_gate_0.nvctrl VGND sg13_hv_nmos ad=1.02p pd=6.68u as=0.57p ps=3.38u w=3u l=0.45u
X66 transmission_gate_2.vout hv_mux4_0.nsel3 ctrl VAPWR sg13_hv_pmos ad=0.95p pd=5.38u as=0.95p ps=5.38u w=5u l=0.45u
X67 transmission_gate_2.vout hv_mux4_0.nsel3 ctrl VAPWR sg13_hv_pmos ad=0.95p pd=5.38u as=0.95p ps=5.38u w=5u l=0.45u
X68 a_2954_8302# hv_mux4_0.nsel1 hv_mux4_0.hv_nor_0.out VAPWR sg13_hv_pmos ad=1.9p pd=10.38u as=1.9p ps=10.38u w=10u l=0.4u
X69 a_1242_318# a_242_282# a_36_1840# VGND sg13_hv_nmos ad=1.14p pd=6.38u as=2.04p ps=12.68u w=6u l=5u
X70 transmission_gate_0.vout transmission_gate_0.nvctrl r2 VAPWR sg13_hv_pmos ad=0.95p pd=5.38u as=1.7p ps=10.68u w=5u l=0.45u
X71 VGND hv_mux4_0.in2 hv_mux4_0.hv_nor4_0.in2 VGND sg13_hv_nmos ad=0.57p pd=3.38u as=0.57p ps=3.38u w=3u l=0.45u
X72 transmission_gate_0.vctrl transmission_gate_0.nvctrl VGND VGND sg13_hv_nmos ad=0.57p pd=3.38u as=0.57p ps=3.38u w=3u l=0.45u
X73 a_10052_3986# a_10052_3986# VGND VGND sg13_hv_nmos ad=2.04p pd=12.68u as=1.14p ps=6.38u w=6u l=5u
X74 VGND hv_mux4_0.hv_nor_0.out hv_inverter_40u_0.in VGND sg13_hv_nmos ad=1.02p pd=6.68u as=0.57p ps=3.38u w=3u l=0.45u
X75 hv_mux4_0.hv_nor_1.out hv_mux4_0.nsel4 VGND VGND sg13_hv_nmos ad=0.57p pd=3.38u as=1.02p ps=6.68u w=3u l=0.45u
X76 VAPWR hv_binary_decoder4_0.hv_nand_0.in1 hv_mux4_0.nsel1 VAPWR sg13_hv_pmos ad=3.4p pd=20.68u as=1.9p ps=10.38u w=10u l=0.4u
X77 hv_mux4_0.in2 vco_0.hv_rs-ff_0.nS a_4364_4622# VGND sg13_hv_nmos ad=0.57p pd=3.38u as=0.57p ps=3.38u w=3u l=0.45u
X78 a_4116_3910# a_4252_1840# VGND rsil l=10u w=0.5u
X79 VGND vco_0.hv_rs-ff_0.nR a_2164_4622# VGND sg13_hv_nmos ad=0.57p pd=3.38u as=0.57p ps=3.38u w=3u l=0.45u
X80 osc_0.out2 transmission_gate_2.vout VAPWR VAPWR sg13_hv_pmos ad=3.4p pd=20.68u as=1.9p ps=10.38u w=10u l=2u
X81 hv_mux4_0.nsel2 hv_binary_decoder4_0.lsb VAPWR VAPWR sg13_hv_pmos ad=1.9p pd=10.38u as=1.9p ps=10.38u w=10u l=0.4u
X82 hv_mux4_0.nsel3 hv_binary_decoder4_0.msb VAPWR VAPWR sg13_hv_pmos ad=1.9p pd=10.38u as=3.4p ps=20.68u w=10u l=0.4u
X83 a_3844_3910# a_3980_1840# VGND rsil l=10u w=0.5u
X84 r1 transmission_gate_1.vctrl transmission_gate_0.vout VGND sg13_hv_nmos ad=0.38p pd=2.38u as=0.38p ps=2.38u w=2u l=0.45u
X85 transmission_gate_2.vout hv_mux4_0.nsel3 ctrl VAPWR sg13_hv_pmos ad=0.95p pd=5.38u as=0.95p ps=5.38u w=5u l=0.45u
X86 VGND hv_mux4_0.nsel3 hv_inverter_40u_1.out VGND sg13_hv_nmos ad=1.02p pd=6.68u as=0.57p ps=3.38u w=3u l=0.45u
X87 ctrl hv_mux4_0.nsel3 transmission_gate_2.vout VAPWR sg13_hv_pmos ad=1.7p pd=10.68u as=0.95p ps=5.38u w=5u l=0.45u
X88 vco_0.bias_current_generator_0.current_reference_40uA_0.iout vco_0.bias_current_generator_0.current_reference_40uA_0.iout VAPWR VAPWR sg13_hv_pmos ad=0.95p pd=5.38u as=1.7p ps=10.68u w=5u l=2u
X89 a_9928_282# vco_0.bias_current_generator_0.current_reference_40uA_0.iout VAPWR VAPWR sg13_hv_pmos ad=0.95p pd=5.38u as=0.95p ps=5.38u w=5u l=2u
X90 VAPWR hv_binary_decoder4_0.lsb hv_mux4_0.nsel2 VAPWR sg13_hv_pmos ad=1.9p pd=10.38u as=1.9p ps=10.38u w=10u l=0.4u
X91 VAPWR vco_0.voltage_mirror_pmos_0.Ibias vco_0.comp_pmos_0.+ VAPWR sg13_hv_pmos ad=1.9p pd=10.38u as=3.4p ps=20.68u w=10u l=2u
X92 hv_inverter_40u_0.in hv_mux4_0.hv_nor_2.out VGND VGND sg13_hv_nmos ad=0.57p pd=3.38u as=0.57p ps=3.38u w=3u l=0.45u
X93 VGND osc_0.c1 osc_0.c1 VGND sg13_hv_nmos ad=0.19p pd=1.38u as=0.34p ps=2.68u w=1u l=2u
X94 transmission_gate_0.vout transmission_gate_0.vctrl r2 VGND sg13_hv_nmos ad=0.38p pd=2.38u as=0.38p ps=2.38u w=2u l=0.45u
X95 r1 transmission_gate_1.vctrl transmission_gate_0.vout VGND sg13_hv_nmos ad=0.38p pd=2.38u as=0.38p ps=2.38u w=2u l=0.45u
X96 pulse_shaper_en_0.low_th_inverter_0.vin hv_inverter_40u_0.in VAPWR VAPWR sg13_hv_pmos ad=0.102p pd=1.28u as=0.102p ps=1.28u w=0.3u l=0.4u
X97 transmission_gate_0.vout transmission_gate_1.nvctrl r1 VAPWR sg13_hv_pmos ad=0.95p pd=5.38u as=0.95p ps=5.38u w=5u l=0.45u
X98 transmission_gate_2.vout hv_inverter_40u_1.out ctrl VGND sg13_hv_nmos ad=0.38p pd=2.38u as=0.38p ps=2.38u w=2u l=0.45u
X99 a_308_3910# a_444_1840# VGND rsil l=10u w=0.5u
X100 a_7354_8302# hv_mux4_0.in3 VAPWR VAPWR sg13_hv_pmos ad=3.4p pd=20.68u as=1.9p ps=10.38u w=10u l=0.4u
X101 a_2934_11830# hv_binary_decoder4_0.hv_nand_0.in1 hv_mux4_0.nsel2 VGND sg13_hv_nmos ad=1.02p pd=6.68u as=0.57p ps=3.38u w=3u l=0.45u
X102 vco_0.nout hv_mux4_0.in2 VAPWR VAPWR sg13_hv_pmos ad=1.9p pd=10.38u as=3.4p ps=20.68u w=10u l=0.4u
X103 transmission_gate_0.vout transmission_gate_0.nvctrl r2 VAPWR sg13_hv_pmos ad=0.95p pd=5.38u as=0.95p ps=5.38u w=5u l=0.45u
X104 a_5154_8302# hv_mux4_0.nsel2 hv_mux4_0.hv_nor4_0.in2 VAPWR sg13_hv_pmos ad=3.4p pd=20.68u as=1.9p ps=10.38u w=10u l=0.4u
X105 r1 transmission_gate_1.nvctrl transmission_gate_0.vout VAPWR sg13_hv_pmos ad=0.95p pd=5.38u as=0.95p ps=5.38u w=5u l=0.45u
X106 VAPWR hv_binary_decoder4_0.lsb hv_binary_decoder4_0.hv_nand_0.in2 VAPWR sg13_hv_pmos ad=3.4p pd=20.68u as=1.9p ps=10.38u w=10u l=0.4u
X107 VGND hv_binary_decoder4_0.msb hv_binary_decoder4_0.hv_nand_0.in1 VGND sg13_hv_nmos ad=1.02p pd=6.68u as=0.57p ps=3.38u w=3u l=0.45u
X108 VGND a_8830_6546# a_8118_6546# VGND sg13_hv_nmos ad=0.228p pd=1.58u as=0.408p ps=3.08u w=1.2u l=1.5u
X109 VGND pulse_shaper_en_0.low_th_inverter_0.vin pulse_shaper_en_0.hv_nor$1_0.in1 VGND sg13_hv_nmos ad=0.34p pd=2.68u as=0.19p ps=1.38u w=1u l=0.45u
X110 a_1940_3910# a_2076_1840# VGND rsil l=10u w=0.5u
X111 vco_0.comp_nmos_0.Ibias vco_0.comp_nmos_0.Ibias VGND VGND sg13_hv_nmos ad=0.408p pd=3.08u as=0.408p ps=3.08u w=1.2u l=1.5u
X112 VAPWR hv_mux4_0.in3 a_7354_8302# VAPWR sg13_hv_pmos ad=1.9p pd=10.38u as=1.9p ps=10.38u w=10u l=0.4u
X113 VGND vco_0.comp_nmos_0.out vco_0.hv_rs-ff_0.nS VGND sg13_hv_nmos ad=0.68p pd=4.68u as=0.68p ps=4.68u w=2u l=0.45u
X114 r1 transmission_gate_1.vctrl transmission_gate_0.vout VGND sg13_hv_nmos ad=0.38p pd=2.38u as=0.38p ps=2.38u w=2u l=0.45u
X115 hv_mux4_0.hv_nor4_0.in2 hv_mux4_0.nsel2 a_5154_8302# VAPWR sg13_hv_pmos ad=1.9p pd=10.38u as=1.9p ps=10.38u w=10u l=0.4u
X116 hv_binary_decoder4_0.hv_nand_0.in2 hv_binary_decoder4_0.lsb VAPWR VAPWR sg13_hv_pmos ad=1.9p pd=10.38u as=1.9p ps=10.38u w=10u l=0.4u
X117 a_11274_1983# a_11274_1983# VAPWR VAPWR sg13_hv_pmos ad=0.95p pd=5.38u as=0.95p ps=5.38u w=5u l=2u
X118 transmission_gate_2.vout hv_inverter_40u_1.out ctrl VGND sg13_hv_nmos ad=0.38p pd=2.38u as=0.38p ps=2.38u w=2u l=0.45u
X119 VAPWR pulse_shaper_en_0.low_th_inverter_0.vin pulse_shaper_en_0.hv_nor$1_0.in1 VAPWR sg13_hv_pmos ad=3.4p pd=20.68u as=1.9p ps=10.38u w=10u l=0.4u
X120 ctrl hv_inverter_40u_1.out transmission_gate_2.vout VGND sg13_hv_nmos ad=0.38p pd=2.38u as=0.38p ps=2.38u w=2u l=0.45u
X121 a_11754_8302# hv_mux4_0.hv_nor4_0.in2 a_12854_8302# VAPWR sg13_hv_pmos ad=1.9p pd=10.38u as=3.4p ps=20.68u w=10u l=0.4u
X122 hv_mux4_0.nsel3 hv_binary_decoder4_0.msb a_5134_11830# VGND sg13_hv_nmos ad=0.57p pd=3.38u as=0.57p ps=3.38u w=3u l=0.45u
X123 pulse_shaper_en_0.low_th_inverter_0.vin hv_inverter_40u_0.in VGND VGND sg13_hv_nmos ad=0.102p pd=1.28u as=0.102p ps=1.28u w=0.3u l=0.45u
X124 vco_0.bias_current_generator_0.5uA- a_14530_2070# VGND VGND sg13_hv_nmos ad=2.04p pd=12.68u as=2.04p ps=12.68u w=6u l=5u
X125 transmission_gate_1.vctrl pulse_shaper_en_0.hv_nor$1_0.in2 VGND VGND sg13_hv_nmos ad=0.57p pd=3.38u as=1.02p ps=6.68u w=3u l=0.45u
X126 transmission_gate_0.nvctrl pulse_shaper_en_0.hv_nand$1_0.in1 VAPWR VAPWR sg13_hv_pmos ad=1.9p pd=10.38u as=1.9p ps=10.38u w=10u l=0.4u
X127 transmission_gate_0.nvctrl pulse_shaper_en_0.en VAPWR VAPWR sg13_hv_pmos ad=1.9p pd=10.38u as=3.4p ps=20.68u w=10u l=0.4u
X128 a_12854_8302# hv_mux4_0.hv_nor_2.out a_13954_8302# VAPWR sg13_hv_pmos ad=1.9p pd=10.38u as=3.4p ps=20.68u w=10u l=0.4u
X129 hv_mux4_0.hv_nor_0.out hv_mux4_0.nsel1 VGND VGND sg13_hv_nmos ad=0.57p pd=3.38u as=0.57p ps=3.38u w=3u l=0.45u
X130 r2 transmission_gate_0.nvctrl transmission_gate_0.vout VAPWR sg13_hv_pmos ad=0.95p pd=5.38u as=0.95p ps=5.38u w=5u l=0.45u
X131 hv_mux4_0.hv_nor_1.out ctrl VGND VGND sg13_hv_nmos ad=0.57p pd=3.38u as=1.02p ps=6.68u w=3u l=0.45u
X132 VAPWR clkin lvl_shift_up_0.hv_inverter_6u5_0.in VAPWR sg13_hv_pmos ad=0.34p pd=2.68u as=0.19p ps=1.38u w=1u l=0.45u
X133 VAPWR transmission_gate_0.nvctrl transmission_gate_0.vctrl VAPWR sg13_hv_pmos ad=3.4p pd=20.68u as=1.9p ps=10.38u w=10u l=0.4u
X134 VAPWR pulse_shaper_en_0.hv_nand$1_0.in1 transmission_gate_0.nvctrl VAPWR sg13_hv_pmos ad=1.9p pd=10.38u as=1.9p ps=10.38u w=10u l=0.4u
X135 hv_binary_decoder4_0.hv_nand_0.in1 hv_binary_decoder4_0.msb VGND VGND sg13_hv_nmos ad=0.57p pd=3.38u as=1.02p ps=6.68u w=3u l=0.45u
X136 osc_0.c2 transmission_gate_2.vout VAPWR VAPWR sg13_hv_pmos ad=0.34p pd=2.68u as=0.19p ps=1.38u w=1u l=2u
X137 a_7334_11830# hv_binary_decoder4_0.msb hv_mux4_0.nsel4 VGND sg13_hv_nmos ad=0.57p pd=3.38u as=0.57p ps=3.38u w=3u l=0.45u
X138 VGND clkin lvl_shift_up_0.hv_inverter_6u5_0.in VGND sg13_hv_nmos ad=3.4p pd=20.68u as=1.9p ps=10.38u w=10u l=0.45u
X139 VGND pulse_shaper_en_0.hv_nor$1_0.in2 transmission_gate_1.vctrl VGND sg13_hv_nmos ad=1.02p pd=6.68u as=0.57p ps=3.38u w=3u l=0.45u
X140 VGND hv_mux4_0.nsel2 hv_mux4_0.hv_nor4_0.in2 VGND sg13_hv_nmos ad=0.57p pd=3.38u as=0.57p ps=3.38u w=3u l=0.45u
X141 a_2164_4622# hv_mux4_0.in2 vco_0.nout VGND sg13_hv_nmos ad=1.02p pd=6.68u as=0.57p ps=3.38u w=3u l=0.45u
X142 pulse_shaper_en_0.hv_nor$1_0.in2 pulse_shaper_en_0.en VGND VGND sg13_hv_nmos ad=0.57p pd=3.38u as=0.57p ps=3.38u w=3u l=0.45u
X143 transmission_gate_0.vout transmission_gate_1.vctrl r1 VGND sg13_hv_nmos ad=0.38p pd=2.38u as=0.38p ps=2.38u w=2u l=0.45u
X144 VGND ctrl hv_mux4_0.hv_nor_1.out VGND sg13_hv_nmos ad=1.02p pd=6.68u as=0.57p ps=3.38u w=3u l=0.45u
X145 hv_mux4_0.hv_nor_2.out hv_mux4_0.in3 VGND VGND sg13_hv_nmos ad=0.57p pd=3.38u as=1.02p ps=6.68u w=3u l=0.45u
X146 clkout hv_inverter_40u_0.in VGND VGND sg13_hv_nmos ad=0.57p pd=3.38u as=1.02p ps=6.68u w=3u l=0.45u
X147 VGND osc_0.c1 osc_0.out2 VGND sg13_hv_nmos ad=0.57p pd=3.38u as=1.02p ps=6.68u w=3u l=0.45u
X148 VGND hv_binary_decoder4_0.hv_nand_0.in2 a_734_11830# VGND sg13_hv_nmos ad=0.57p pd=3.38u as=1.02p ps=6.68u w=3u l=0.45u
X149 hv_mux4_0.nsel2 hv_binary_decoder4_0.hv_nand_0.in1 VAPWR VAPWR sg13_hv_pmos ad=1.9p pd=10.38u as=1.9p ps=10.38u w=10u l=0.4u
X150 hv_mux4_0.nsel2 hv_binary_decoder4_0.lsb VAPWR VAPWR sg13_hv_pmos ad=1.9p pd=10.38u as=3.4p ps=20.68u w=10u l=0.4u
X151 transmission_gate_0.vout transmission_gate_0.vctrl r2 VGND sg13_hv_nmos ad=0.38p pd=2.38u as=0.38p ps=2.38u w=2u l=0.45u
X152 a_11754_8302# hv_mux4_0.hv_nor_0.out hv_inverter_40u_0.in VAPWR sg13_hv_pmos ad=1.9p pd=10.38u as=1.9p ps=10.38u w=10u l=0.4u
X153 ctrl hv_mux4_0.nsel3 transmission_gate_2.vout VAPWR sg13_hv_pmos ad=0.95p pd=5.38u as=0.95p ps=5.38u w=5u l=0.45u
X154 transmission_gate_0.vout transmission_gate_0.nvctrl r2 VAPWR sg13_hv_pmos ad=0.95p pd=5.38u as=0.95p ps=5.38u w=5u l=0.45u
X155 a_12854_8302# hv_mux4_0.hv_nor4_0.in2 a_11754_8302# VAPWR sg13_hv_pmos ad=1.9p pd=10.38u as=1.9p ps=10.38u w=10u l=0.4u
X156 VGND pulse_shaper_en_0.en a_13934_11830# VGND sg13_hv_nmos ad=0.57p pd=3.38u as=0.57p ps=3.38u w=3u l=0.45u
X157 VAPWR hv_binary_decoder4_0.hv_nand_0.in1 hv_mux4_0.nsel2 VAPWR sg13_hv_pmos ad=1.9p pd=10.38u as=1.9p ps=10.38u w=10u l=0.4u
X158 r2 transmission_gate_0.vctrl transmission_gate_0.vout VGND sg13_hv_nmos ad=0.38p pd=2.38u as=0.38p ps=2.38u w=2u l=0.45u
X159 hv_inverter_40u_0.in hv_mux4_0.hv_nor4_0.in2 VGND VGND sg13_hv_nmos ad=0.57p pd=3.38u as=0.57p ps=3.38u w=3u l=0.45u
X160 VGND hv_mux4_0.in3 hv_mux4_0.hv_nor_2.out VGND sg13_hv_nmos ad=1.02p pd=6.68u as=0.57p ps=3.38u w=3u l=0.45u
X161 VAPWR vco_0.voltage_mirror_pmos_0.Ibias vco_0.voltage_mirror_pmos_0.Ibias VAPWR sg13_hv_pmos ad=3.23p pd=19.68u as=1.805p ps=9.88u w=9.5u l=2u
X162 hv_mux4_0.in2 vco_0.hv_rs-ff_0.nS a_4364_4622# VGND sg13_hv_nmos ad=0.57p pd=3.38u as=1.02p ps=6.68u w=3u l=0.45u
X163 r1 transmission_gate_1.nvctrl transmission_gate_0.vout VAPWR sg13_hv_pmos ad=0.95p pd=5.38u as=0.95p ps=5.38u w=5u l=0.45u
X164 VGND vco_0.hv_rs-ff_0.nR a_2164_4622# VGND sg13_hv_nmos ad=0.57p pd=3.38u as=1.02p ps=6.68u w=3u l=0.45u
X165 r1 transmission_gate_1.vctrl transmission_gate_0.vout VGND sg13_hv_nmos ad=0.38p pd=2.38u as=0.38p ps=2.38u w=2u l=0.45u
X166 a_1396_3910# a_1532_1840# VGND rsil l=10u w=0.5u
X167 VGND pulse_shaper_en_0.low_th_inverter_0.vin pulse_shaper_en_0.hv_nand$1_0.in1 VGND sg13_hv_nmos ad=0.34p pd=2.68u as=0.19p ps=1.38u w=1u l=0.45u
X168 a_734_11830# hv_binary_decoder4_0.hv_nand_0.in2 VGND VGND sg13_hv_nmos ad=1.02p pd=6.68u as=0.57p ps=3.38u w=3u l=0.45u
X169 VGND a_9928_282# a_9928_282# VGND sg13_hv_nmos ad=1.14p pd=6.38u as=1.14p ps=6.38u w=6u l=5u
X170 a_9850_7890# a_9986_5544# VGND rhigh l=11.3u w=0.5u
X171 transmission_gate_0.vout transmission_gate_1.nvctrl r1 VAPWR sg13_hv_pmos ad=0.95p pd=5.38u as=0.95p ps=5.38u w=5u l=0.45u
X172 ctrl hv_mux4_0.nsel3 transmission_gate_2.vout VAPWR sg13_hv_pmos ad=0.95p pd=5.38u as=0.95p ps=5.38u w=5u l=0.45u
X173 VAPWR lvl_shift_up_2.hv_inverter_6u5_0.in pulse_shaper_en_0.en VAPWR sg13_hv_pmos ad=2.21p pd=13.68u as=2.21p ps=13.68u w=6.5u l=0.4u
X174 VAPWR vco_0.comp_nmos_0.out vco_0.hv_rs-ff_0.nS VAPWR sg13_hv_pmos ad=2.21p pd=13.68u as=2.21p ps=13.68u w=6.5u l=0.4u
X175 VGND lvl_shift_up_1.hv_inverter_6u5_0.in hv_binary_decoder4_0.msb VGND sg13_hv_nmos ad=0.68p pd=4.68u as=0.68p ps=4.68u w=2u l=0.45u
X176 VAPWR pulse_shaper_en_0.low_th_inverter_0.vin pulse_shaper_en_0.hv_nand$1_0.in1 VAPWR sg13_hv_pmos ad=0.34p pd=2.68u as=0.19p ps=1.38u w=1u l=0.4u
X177 a_11274_1983# a_11274_1983# VAPWR VAPWR sg13_hv_pmos ad=0.95p pd=5.38u as=0.95p ps=5.38u w=5u l=2u
X178 hv_mux4_0.in2 vco_0.nout VAPWR VAPWR sg13_hv_pmos ad=1.9p pd=10.38u as=1.9p ps=10.38u w=10u l=0.4u
X179 VGND hv_mux4_0.hv_nor_1.out hv_inverter_40u_0.in VGND sg13_hv_nmos ad=0.57p pd=3.38u as=0.57p ps=3.38u w=3u l=0.45u
X180 pulse_shaper_en_0.hv_nand$1_0.in1 pulse_shaper_en_0.low_th_inverter_0.vin VAPWR VAPWR sg13_hv_pmos ad=0.19p pd=1.38u as=0.34p ps=2.68u w=1u l=0.4u
X181 VAPWR vco_0.nout hv_mux4_0.in2 VAPWR sg13_hv_pmos ad=1.9p pd=10.38u as=1.9p ps=10.38u w=10u l=0.4u
X182 VGND hv_binary_decoder4_0.lsb a_2934_11830# VGND sg13_hv_nmos ad=0.57p pd=3.38u as=0.57p ps=3.38u w=3u l=0.45u
X183 vco_0.voltage_mirror_pmos_0.Ibias a_12472_3966# VGND rhigh l=6.78u w=0.5u
X184 VAPWR hv_mux4_0.hv_nor_1.out a_13954_8302# VAPWR sg13_hv_pmos ad=3.4p pd=20.68u as=1.9p ps=10.38u w=10u l=0.4u
X185 transmission_gate_1.vctrl pulse_shaper_en_0.hv_nor$1_0.in1 VGND VGND sg13_hv_nmos ad=0.57p pd=3.38u as=1.02p ps=6.68u w=3u l=0.45u
X186 VAPWR pulse_shaper_en_0.hv_nor$1_0.in2 a_11754_12982# VAPWR sg13_hv_pmos ad=1.9p pd=10.38u as=1.9p ps=10.38u w=10u l=0.4u
X187 transmission_gate_0.nvctrl pulse_shaper_en_0.hv_nand$1_0.in1 VAPWR VAPWR sg13_hv_pmos ad=1.9p pd=10.38u as=3.4p ps=20.68u w=10u l=0.4u
X188 a_3300_3910# a_3436_1840# VGND rsil l=10u w=0.5u
X189 a_11754_8302# hv_mux4_0.hv_nor_0.out hv_inverter_40u_0.in VAPWR sg13_hv_pmos ad=3.4p pd=20.68u as=1.9p ps=10.38u w=10u l=0.4u
X190 transmission_gate_2.vout hv_mux4_0.nsel3 ctrl VAPWR sg13_hv_pmos ad=0.95p pd=5.38u as=0.95p ps=5.38u w=5u l=0.45u
X191 a_9116_3986# a_9116_3986# VAPWR VAPWR sg13_hv_pmos ad=0.68p pd=4.68u as=0.38p ps=2.38u w=2u l=0.4u
X192 hv_binary_decoder4_0.hv_nand_0.in2 hv_binary_decoder4_0.lsb VGND VGND sg13_hv_nmos ad=0.57p pd=3.38u as=0.57p ps=3.38u w=3u l=0.45u
X193 VPWR hv_inverter_40u_0.in clkout VPWR sg13_hv_pmos ad=1.9p pd=10.38u as=1.9p ps=10.38u w=10u l=0.4u
X194 transmission_gate_0.vout transmission_gate_0.vctrl r2 VGND sg13_hv_nmos ad=0.38p pd=2.38u as=0.38p ps=2.38u w=2u l=0.45u
X195 VAPWR pulse_shaper_en_0.en pulse_shaper_en_0.hv_nor$1_0.in2 VAPWR sg13_hv_pmos ad=3.4p pd=20.68u as=1.9p ps=10.38u w=10u l=0.4u
X196 transmission_gate_0.vout transmission_gate_1.nvctrl r1 VAPWR sg13_hv_pmos ad=0.95p pd=5.38u as=0.95p ps=5.38u w=5u l=0.45u
X197 transmission_gate_0.vout transmission_gate_1.vctrl r1 VGND sg13_hv_nmos ad=0.38p pd=2.38u as=0.38p ps=2.38u w=2u l=0.45u
X198 a_13954_8302# hv_mux4_0.hv_nor_1.out VAPWR VAPWR sg13_hv_pmos ad=1.9p pd=10.38u as=1.9p ps=10.38u w=10u l=0.4u
X199 a_11754_12982# pulse_shaper_en_0.hv_nor$1_0.in2 VAPWR VAPWR sg13_hv_pmos ad=1.9p pd=10.38u as=1.9p ps=10.38u w=10u l=0.4u
X200 a_4588_4120# VGND VGND rppd l=10.95u w=2u
X201 hv_inverter_40u_0.in hv_mux4_0.hv_nor_0.out a_11754_8302# VAPWR sg13_hv_pmos ad=1.9p pd=10.38u as=1.9p ps=10.38u w=10u l=0.4u
X202 vco_0.bias_current_generator_0.5uA+ a_11274_1983# VAPWR VAPWR sg13_hv_pmos ad=0.95p pd=5.38u as=0.95p ps=5.38u w=5u l=2u
X203 ctrl hv_inverter_40u_1.out transmission_gate_2.vout VGND sg13_hv_nmos ad=0.38p pd=2.38u as=0.38p ps=2.38u w=2u l=0.45u
X204 VAPWR hv_binary_decoder4_0.lsb hv_mux4_0.nsel4 VAPWR sg13_hv_pmos ad=3.4p pd=20.68u as=1.9p ps=10.38u w=10u l=0.4u
X205 VAPWR a_9116_3986# a_8484_3986# VAPWR sg13_hv_pmos ad=0.38p pd=2.38u as=0.68p ps=4.68u w=2u l=0.4u
X206 clkout hv_inverter_40u_0.in VPWR VPWR sg13_hv_pmos ad=1.9p pd=10.38u as=3.4p ps=20.68u w=10u l=0.4u
X207 transmission_gate_2.vout hv_inverter_40u_1.out ctrl VGND sg13_hv_nmos ad=0.38p pd=2.38u as=0.38p ps=2.38u w=2u l=0.45u
X208 r2 transmission_gate_0.nvctrl transmission_gate_0.vout VAPWR sg13_hv_pmos ad=0.95p pd=5.38u as=0.95p ps=5.38u w=5u l=0.45u
X209 a_5134_11830# hv_binary_decoder4_0.hv_nand_0.in2 VGND VGND sg13_hv_nmos ad=0.57p pd=3.38u as=0.57p ps=3.38u w=3u l=0.45u
X210 VGND pulse_shaper_en_0.hv_nor$1_0.in1 transmission_gate_1.vctrl VGND sg13_hv_nmos ad=1.02p pd=6.68u as=0.57p ps=3.38u w=3u l=0.45u
X211 VGND hv_mux4_0.in1 hv_mux4_0.hv_nor_0.out VGND sg13_hv_nmos ad=0.57p pd=3.38u as=0.57p ps=3.38u w=3u l=0.45u
X212 transmission_gate_1.nvctrl transmission_gate_1.vctrl VGND VGND sg13_hv_nmos ad=0.57p pd=3.38u as=0.57p ps=3.38u w=3u l=0.45u
X213 VAPWR a_1242_318# a_1242_318# VAPWR sg13_hv_pmos ad=1.9p pd=10.38u as=3.4p ps=20.68u w=10u l=2u
X214 r1 transmission_gate_1.vctrl transmission_gate_0.vout VGND sg13_hv_nmos ad=0.38p pd=2.38u as=0.38p ps=2.38u w=2u l=0.45u
X215 VGND hv_mux4_0.nsel4 hv_mux4_0.hv_nor_1.out VGND sg13_hv_nmos ad=1.02p pd=6.68u as=0.57p ps=3.38u w=3u l=0.45u
X216 hv_mux4_0.hv_nor_2.out hv_mux4_0.nsel3 VGND VGND sg13_hv_nmos ad=0.57p pd=3.38u as=1.02p ps=6.68u w=3u l=0.45u
X217 r2 transmission_gate_0.nvctrl transmission_gate_0.vout VAPWR sg13_hv_pmos ad=0.95p pd=5.38u as=0.95p ps=5.38u w=5u l=0.45u
X218 VAPWR lvl_shift_up_1.hv_inverter_6u5_0.in hv_binary_decoder4_0.msb VAPWR sg13_hv_pmos ad=2.21p pd=13.68u as=2.21p ps=13.68u w=6.5u l=0.4u
X219 VAPWR hv_mux4_0.in2 vco_0.nout VAPWR sg13_hv_pmos ad=3.4p pd=20.68u as=1.9p ps=10.38u w=10u l=0.4u
X220 transmission_gate_2.vout hv_inverter_40u_1.out ctrl VGND sg13_hv_nmos ad=0.38p pd=2.38u as=0.68p ps=4.68u w=2u l=0.45u
X221 transmission_gate_2.vout hv_inverter_40u_1.out ctrl VGND sg13_hv_nmos ad=0.38p pd=2.38u as=0.38p ps=2.38u w=2u l=0.45u
X222 a_2164_4622# hv_mux4_0.in2 vco_0.nout VGND sg13_hv_nmos ad=0.57p pd=3.38u as=0.57p ps=3.38u w=3u l=0.45u
X223 hv_mux4_0.nsel1 hv_binary_decoder4_0.hv_nand_0.in2 VAPWR VAPWR sg13_hv_pmos ad=1.9p pd=10.38u as=1.9p ps=10.38u w=10u l=0.4u
X224 hv_mux4_0.nsel2 hv_binary_decoder4_0.hv_nand_0.in1 VAPWR VAPWR sg13_hv_pmos ad=1.9p pd=10.38u as=3.4p ps=20.68u w=10u l=0.4u
X225 r1 transmission_gate_1.nvctrl transmission_gate_0.vout VAPWR sg13_hv_pmos ad=1.7p pd=10.68u as=0.95p ps=5.38u w=5u l=0.45u
X226 ctrl hv_mux4_0.nsel3 transmission_gate_2.vout VAPWR sg13_hv_pmos ad=0.95p pd=5.38u as=0.95p ps=5.38u w=5u l=0.45u
X227 r2 transmission_gate_0.nvctrl transmission_gate_0.vout VAPWR sg13_hv_pmos ad=0.95p pd=5.38u as=0.95p ps=5.38u w=5u l=0.45u
X228 transmission_gate_0.nvctrl pulse_shaper_en_0.hv_nand$1_0.in1 a_13934_11830# VGND sg13_hv_nmos ad=0.57p pd=3.38u as=0.57p ps=3.38u w=3u l=0.45u
X229 VAPWR hv_binary_decoder4_0.hv_nand_0.in2 hv_mux4_0.nsel1 VAPWR sg13_hv_pmos ad=1.9p pd=10.38u as=1.9p ps=10.38u w=10u l=0.4u
X230 VGND transmission_gate_0.nvctrl transmission_gate_0.vctrl VGND sg13_hv_nmos ad=0.57p pd=3.38u as=0.57p ps=3.38u w=3u l=0.45u
X231 hv_inverter_40u_0.in hv_mux4_0.hv_nor_0.out VGND VGND sg13_hv_nmos ad=0.57p pd=3.38u as=0.57p ps=3.38u w=3u l=0.45u
X232 osc_0.c2 osc_0.c2 VGND VGND sg13_hv_nmos ad=0.34p pd=2.68u as=0.19p ps=1.38u w=1u l=2u
X233 a_12608_5408# a_12472_3966# VGND rhigh l=6.78u w=0.5u
X234 hv_binary_decoder4_0.hv_nand_0.in2 hv_binary_decoder4_0.lsb VAPWR VAPWR sg13_hv_pmos ad=1.9p pd=10.38u as=3.4p ps=20.68u w=10u l=0.4u
X235 a_4588_4120# a_4252_1840# VGND rppd l=10.95u w=2u
X236 vco_0.vc hv_mux4_0.in2 vco_0.bias_current_generator_0.5uA+ VAPWR sg13_hv_pmos ad=0.102p pd=1.28u as=0.102p ps=1.28u w=0.3u l=0.4u
X237 hv_mux4_0.hv_nor_1.out hv_mux4_0.nsel4 a_9554_8302# VAPWR sg13_hv_pmos ad=1.9p pd=10.38u as=3.4p ps=20.68u w=10u l=0.4u
X238 transmission_gate_2.vout hv_inverter_40u_1.out ctrl VGND sg13_hv_nmos ad=0.38p pd=2.38u as=0.38p ps=2.38u w=2u l=0.45u
X239 VAPWR hv_mux4_0.in2 a_5154_8302# VAPWR sg13_hv_pmos ad=1.9p pd=10.38u as=3.4p ps=20.68u w=10u l=0.4u
X240 hv_mux4_0.hv_nor_0.out hv_mux4_0.nsel1 a_2954_8302# VAPWR sg13_hv_pmos ad=1.9p pd=10.38u as=3.4p ps=20.68u w=10u l=0.4u
X241 a_734_11830# hv_binary_decoder4_0.hv_nand_0.in1 hv_mux4_0.nsel1 VGND sg13_hv_nmos ad=1.02p pd=6.68u as=0.57p ps=3.38u w=3u l=0.45u
X242 hv_inverter_40u_1.out hv_mux4_0.nsel3 VGND VGND sg13_hv_nmos ad=0.57p pd=3.38u as=0.57p ps=3.38u w=3u l=0.45u
X243 transmission_gate_0.vout transmission_gate_1.vctrl r1 VGND sg13_hv_nmos ad=0.38p pd=2.38u as=0.38p ps=2.38u w=2u l=0.45u
X244 a_852_3910# a_716_1840# VGND rsil l=10u w=0.5u
X245 VGND hv_mux4_0.hv_nor_2.out hv_inverter_40u_0.in VGND sg13_hv_nmos ad=0.57p pd=3.38u as=0.57p ps=3.38u w=3u l=0.45u
X246 VAPWR lvl_shift_up_3.hv_inverter_6u5_0.in hv_binary_decoder4_0.lsb VAPWR sg13_hv_pmos ad=2.21p pd=13.68u as=2.21p ps=13.68u w=6.5u l=0.4u
X247 a_2484_3910# a_2348_1840# VGND rsil l=10u w=0.5u
X248 r2 transmission_gate_0.vctrl transmission_gate_0.vout VGND sg13_hv_nmos ad=0.38p pd=2.38u as=0.38p ps=2.38u w=2u l=0.45u
X249 transmission_gate_0.vout transmission_gate_1.nvctrl r1 VAPWR sg13_hv_pmos ad=0.95p pd=5.38u as=0.95p ps=5.38u w=5u l=0.45u
X250 hv_mux4_0.nsel2 hv_binary_decoder4_0.hv_nand_0.in1 a_2934_11830# VGND sg13_hv_nmos ad=0.57p pd=3.38u as=0.57p ps=3.38u w=3u l=0.45u
X251 transmission_gate_1.vctrl pulse_shaper_en_0.hv_nor$1_0.in1 a_11754_12982# VAPWR sg13_hv_pmos ad=1.9p pd=10.38u as=1.9p ps=10.38u w=10u l=0.4u
X252 vco_0.hv_inverter_6u5$2_0.in a_8118_6546# VGND VGND sg13_hv_nmos ad=0.408p pd=3.08u as=0.408p ps=3.08u w=1.2u l=1.5u
X253 transmission_gate_0.vout transmission_gate_0.nvctrl r2 VAPWR sg13_hv_pmos ad=0.95p pd=5.38u as=0.95p ps=5.38u w=5u l=0.45u
X254 VGND vco_0.hv_inverter_6u5$2_0.in vco_0.hv_rs-ff_0.nR VGND sg13_hv_nmos ad=0.68p pd=4.68u as=0.68p ps=4.68u w=2u l=0.45u
X255 hv_binary_decoder4_0.hv_nand_0.in1 hv_binary_decoder4_0.msb VGND VGND sg13_hv_nmos ad=0.57p pd=3.38u as=0.57p ps=3.38u w=3u l=0.45u
X256 r2 transmission_gate_0.vctrl transmission_gate_0.vout VGND sg13_hv_nmos ad=0.38p pd=2.38u as=0.38p ps=2.38u w=2u l=0.45u
X257 VAPWR transmission_gate_1.vctrl transmission_gate_1.nvctrl VAPWR sg13_hv_pmos ad=3.4p pd=20.68u as=1.9p ps=10.38u w=10u l=0.4u
X258 r2 transmission_gate_0.vctrl transmission_gate_0.vout VGND sg13_hv_nmos ad=0.38p pd=2.38u as=0.38p ps=2.38u w=2u l=0.45u
X259 r1 transmission_gate_1.nvctrl transmission_gate_0.vout VAPWR sg13_hv_pmos ad=0.95p pd=5.38u as=0.95p ps=5.38u w=5u l=0.45u
X260 hv_mux4_0.nsel1 hv_binary_decoder4_0.hv_nand_0.in1 a_734_11830# VGND sg13_hv_nmos ad=0.57p pd=3.38u as=1.02p ps=6.68u w=3u l=0.45u
X261 vco_0.comp_nmos_0.Ibias vco_0.bias_current_generator_0.current_reference_40uA_0.iout VAPWR VAPWR sg13_hv_pmos ad=0.95p pd=5.38u as=0.95p ps=5.38u w=5u l=2u
X262 VAPWR hv_binary_decoder4_0.msb hv_mux4_0.nsel4 VAPWR sg13_hv_pmos ad=3.4p pd=20.68u as=1.9p ps=10.38u w=10u l=0.4u
X263 a_7354_8302# hv_mux4_0.in3 VAPWR VAPWR sg13_hv_pmos ad=1.9p pd=10.38u as=1.9p ps=10.38u w=10u l=0.4u
X264 a_5154_8302# hv_mux4_0.nsel2 hv_mux4_0.hv_nor4_0.in2 VAPWR sg13_hv_pmos ad=1.9p pd=10.38u as=1.9p ps=10.38u w=10u l=0.4u
X265 VAPWR hv_binary_decoder4_0.lsb hv_binary_decoder4_0.hv_nand_0.in2 VAPWR sg13_hv_pmos ad=1.9p pd=10.38u as=1.9p ps=10.38u w=10u l=0.4u
X266 a_5134_11830# hv_binary_decoder4_0.msb hv_mux4_0.nsel3 VGND sg13_hv_nmos ad=0.57p pd=3.38u as=0.57p ps=3.38u w=3u l=0.45u
X267 VGND hv_binary_decoder4_0.lsb a_7334_11830# VGND sg13_hv_nmos ad=0.57p pd=3.38u as=1.02p ps=6.68u w=3u l=0.45u
X268 VGND hv_mux4_0.nsel1 hv_mux4_0.hv_nor_0.out VGND sg13_hv_nmos ad=0.57p pd=3.38u as=0.57p ps=3.38u w=3u l=0.45u
X269 ctrl hv_mux4_0.nsel3 transmission_gate_2.vout VAPWR sg13_hv_pmos ad=0.95p pd=5.38u as=0.95p ps=5.38u w=5u l=0.45u
X270 hv_mux4_0.hv_nor4_0.in2 hv_mux4_0.in2 VGND VGND sg13_hv_nmos ad=0.57p pd=3.38u as=1.02p ps=6.68u w=3u l=0.45u
X271 VGND vco_0.nout a_4364_4622# VGND sg13_hv_nmos ad=0.57p pd=3.38u as=0.57p ps=3.38u w=3u l=0.45u
X272 r2 transmission_gate_0.nvctrl transmission_gate_0.vout VAPWR sg13_hv_pmos ad=0.95p pd=5.38u as=0.95p ps=5.38u w=5u l=0.45u
X273 hv_mux4_0.nsel1 hv_binary_decoder4_0.hv_nand_0.in1 VAPWR VAPWR sg13_hv_pmos ad=1.9p pd=10.38u as=1.9p ps=10.38u w=10u l=0.4u
X274 a_14530_2070# a_11274_1983# VAPWR VAPWR sg13_hv_pmos ad=0.95p pd=5.38u as=0.95p ps=5.38u w=5u l=2u
X275 transmission_gate_1.vctrl pulse_shaper_en_0.hv_nor$1_0.in2 VGND VGND sg13_hv_nmos ad=0.57p pd=3.38u as=0.57p ps=3.38u w=3u l=0.45u
X276 a_7334_11830# hv_binary_decoder4_0.lsb VGND VGND sg13_hv_nmos ad=1.02p pd=6.68u as=0.57p ps=3.38u w=3u l=0.45u
X277 VAPWR hv_mux4_0.nsel3 hv_inverter_40u_1.out VAPWR sg13_hv_pmos ad=3.4p pd=20.68u as=1.9p ps=10.38u w=10u l=0.4u
X278 transmission_gate_0.vout transmission_gate_0.vctrl r2 VGND sg13_hv_nmos ad=0.38p pd=2.38u as=0.38p ps=2.38u w=2u l=0.45u
X279 VGND pulse_shaper_en_0.en pulse_shaper_en_0.hv_nor$1_0.in2 VGND sg13_hv_nmos ad=0.57p pd=3.38u as=0.57p ps=3.38u w=3u l=0.45u
X280 r2 transmission_gate_0.vctrl transmission_gate_0.vout VGND sg13_hv_nmos ad=0.38p pd=2.38u as=0.38p ps=2.38u w=2u l=0.45u
X281 transmission_gate_0.vout transmission_gate_1.nvctrl r1 VAPWR sg13_hv_pmos ad=0.95p pd=5.38u as=0.95p ps=5.38u w=5u l=0.45u
X282 hv_mux4_0.hv_nor_1.out ctrl VGND VGND sg13_hv_nmos ad=0.57p pd=3.38u as=0.57p ps=3.38u w=3u l=0.45u
X283 transmission_gate_0.vout transmission_gate_1.vctrl r1 VGND sg13_hv_nmos ad=0.38p pd=2.38u as=0.38p ps=2.38u w=2u l=0.45u
X284 VGND hv_mux4_0.nsel3 hv_mux4_0.hv_nor_2.out VGND sg13_hv_nmos ad=1.02p pd=6.68u as=0.57p ps=3.38u w=3u l=0.45u
X285 r1 transmission_gate_1.nvctrl transmission_gate_0.vout VAPWR sg13_hv_pmos ad=0.95p pd=5.38u as=0.95p ps=5.38u w=5u l=0.45u
X286 hv_mux4_0.in2 vco_0.hv_rs-ff_0.nS VAPWR VAPWR sg13_hv_pmos ad=1.9p pd=10.38u as=3.4p ps=20.68u w=10u l=0.4u
X287 VPWR hv_inverter_40u_0.in clkout VPWR sg13_hv_pmos ad=3.4p pd=20.68u as=1.9p ps=10.38u w=10u l=0.4u
X288 a_7354_8302# hv_mux4_0.nsel3 hv_mux4_0.hv_nor_2.out VAPWR sg13_hv_pmos ad=3.4p pd=20.68u as=1.9p ps=10.38u w=10u l=0.4u
X289 vco_0.nout vco_0.hv_rs-ff_0.nR VAPWR VAPWR sg13_hv_pmos ad=1.9p pd=10.38u as=3.4p ps=20.68u w=10u l=0.4u
X290 a_2954_8302# hv_mux4_0.in1 VAPWR VAPWR sg13_hv_pmos ad=3.4p pd=20.68u as=1.9p ps=10.38u w=10u l=0.4u
X291 VAPWR hv_binary_decoder4_0.msb hv_binary_decoder4_0.hv_nand_0.in1 VAPWR sg13_hv_pmos ad=3.4p pd=20.68u as=1.9p ps=10.38u w=10u l=0.4u
X292 ctrl hv_inverter_40u_1.out transmission_gate_2.vout VGND sg13_hv_nmos ad=0.38p pd=2.38u as=0.38p ps=2.38u w=2u l=0.45u
X293 a_36_3910# a_172_1840# VGND rsil l=10u w=0.5u
X294 a_2212_3910# a_2076_1840# VGND rsil l=10u w=0.5u
X295 VGND hv_inverter_40u_0.in clkout VGND sg13_hv_nmos ad=1.02p pd=6.68u as=0.57p ps=3.38u w=3u l=0.45u
X296 hv_mux4_0.hv_nor_2.out hv_mux4_0.nsel3 a_7354_8302# VAPWR sg13_hv_pmos ad=1.9p pd=10.38u as=1.9p ps=10.38u w=10u l=0.4u
X297 transmission_gate_2.vout hv_mux4_0.nsel3 ctrl VAPWR sg13_hv_pmos ad=0.95p pd=5.38u as=0.95p ps=5.38u w=5u l=0.45u
X298 a_1940_3910# a_1804_1840# VGND rsil l=10u w=0.5u
X299 r1 transmission_gate_1.vctrl transmission_gate_0.vout VGND sg13_hv_nmos ad=0.38p pd=2.38u as=0.38p ps=2.38u w=2u l=0.45u
X300 VAPWR hv_mux4_0.in1 a_2954_8302# VAPWR sg13_hv_pmos ad=1.9p pd=10.38u as=1.9p ps=10.38u w=10u l=0.4u
X301 a_13934_11830# pulse_shaper_en_0.en VGND VGND sg13_hv_nmos ad=0.57p pd=3.38u as=0.57p ps=3.38u w=3u l=0.45u
X302 hv_binary_decoder4_0.hv_nand_0.in1 hv_binary_decoder4_0.msb VAPWR VAPWR sg13_hv_pmos ad=1.9p pd=10.38u as=1.9p ps=10.38u w=10u l=0.4u
X303 VGND hv_mux4_0.hv_nor4_0.in2 hv_inverter_40u_0.in VGND sg13_hv_nmos ad=0.57p pd=3.38u as=0.57p ps=3.38u w=3u l=0.45u
X304 transmission_gate_0.vout transmission_gate_0.nvctrl r2 VAPWR sg13_hv_pmos ad=0.95p pd=5.38u as=0.95p ps=5.38u w=5u l=0.45u
X305 hv_mux4_0.hv_nor_1.out hv_mux4_0.nsel4 VGND VGND sg13_hv_nmos ad=0.57p pd=3.38u as=0.57p ps=3.38u w=3u l=0.45u
X306 a_9196_4974# vco_0.comp_nmos_0.Ibias VGND VGND sg13_hv_nmos ad=0.816p pd=5.48u as=0.456p ps=2.78u w=2.4u l=1.5u
X307 hv_inverter_40u_0.in hv_mux4_0.hv_nor_0.out a_11754_8302# VAPWR sg13_hv_pmos ad=1.9p pd=10.38u as=3.4p ps=20.68u w=10u l=0.4u
X308 VGND en lvl_shift_up_2.hv_inverter_6u5_0.in VGND sg13_hv_nmos ad=3.4p pd=20.68u as=1.9p ps=10.38u w=10u l=0.45u
X309 pulse_shaper_en_0.hv_nand$1_0.in1 pulse_shaper_en_0.low_th_inverter_0.vin VGND VGND sg13_hv_nmos ad=0.19p pd=1.38u as=0.34p ps=2.68u w=1u l=0.45u
X310 VGND hv_binary_decoder4_0.hv_nand_0.in2 a_734_11830# VGND sg13_hv_nmos ad=0.57p pd=3.38u as=0.57p ps=3.38u w=3u l=0.45u
X311 pulse_shaper_en_0.hv_nor$1_0.in1 pulse_shaper_en_0.low_th_inverter_0.vin VAPWR VAPWR sg13_hv_pmos ad=1.9p pd=10.38u as=3.4p ps=20.68u w=10u l=0.4u
X312 VAPWR pulse_shaper_en_0.hv_nor$1_0.in2 a_11754_12982# VAPWR sg13_hv_pmos ad=1.9p pd=10.38u as=3.4p ps=20.68u w=10u l=0.4u
X313 r2 transmission_gate_0.nvctrl transmission_gate_0.vout VAPWR sg13_hv_pmos ad=0.95p pd=5.38u as=0.95p ps=5.38u w=5u l=0.45u
X314 transmission_gate_2.vout hv_mux4_0.nsel3 ctrl VAPWR sg13_hv_pmos ad=0.95p pd=5.38u as=0.95p ps=5.38u w=5u l=0.45u
X315 ctrl hv_mux4_0.nsel3 transmission_gate_2.vout VAPWR sg13_hv_pmos ad=0.95p pd=5.38u as=0.95p ps=5.38u w=5u l=0.45u
X316 VAPWR vco_0.bias_current_generator_0.current_reference_40uA_0.iout a_9928_282# VAPWR sg13_hv_pmos ad=0.95p pd=5.38u as=0.95p ps=5.38u w=5u l=2u
X317 r1 transmission_gate_1.vctrl transmission_gate_0.vout VGND sg13_hv_nmos ad=0.38p pd=2.38u as=0.38p ps=2.38u w=2u l=0.45u
X318 a_4116_3910# a_3980_1840# VGND rsil l=10u w=0.5u
X319 a_12880_5408# a_12744_3966# VGND rhigh l=6.78u w=0.5u
X320 a_11754_12982# pulse_shaper_en_0.hv_nor$1_0.in1 transmission_gate_1.vctrl VAPWR sg13_hv_pmos ad=1.9p pd=10.38u as=1.9p ps=10.38u w=10u l=0.4u
X321 VAPWR vco_0.bias_current_generator_0.current_reference_40uA_0.iout vco_0.bias_current_generator_0.current_reference_40uA_0.iout VAPWR sg13_hv_pmos ad=0.95p pd=5.38u as=0.95p ps=5.38u w=5u l=2u
X322 a_3844_3910# a_3708_1840# VGND rsil l=10u w=0.5u
X323 a_8648_7374# vco_0.comp_pmos_0.Ibias VAPWR VAPWR sg13_hv_pmos ad=0.68p pd=4.68u as=0.38p ps=2.38u w=2u l=0.4u
X324 r2 transmission_gate_0.vctrl transmission_gate_0.vout VGND sg13_hv_nmos ad=0.38p pd=2.38u as=0.38p ps=2.38u w=2u l=0.45u
X325 VAPWR hv_binary_decoder4_0.hv_nand_0.in2 hv_mux4_0.nsel3 VAPWR sg13_hv_pmos ad=3.4p pd=20.68u as=1.9p ps=10.38u w=10u l=0.4u
X326 transmission_gate_0.vctrl transmission_gate_0.nvctrl VAPWR VAPWR sg13_hv_pmos ad=1.9p pd=10.38u as=1.9p ps=10.38u w=10u l=0.4u
X327 a_2934_11830# hv_binary_decoder4_0.lsb VGND VGND sg13_hv_nmos ad=0.57p pd=3.38u as=0.57p ps=3.38u w=3u l=0.45u
X328 a_2164_4622# vco_0.hv_rs-ff_0.nR VGND VGND sg13_hv_nmos ad=1.02p pd=6.68u as=0.57p ps=3.38u w=3u l=0.45u
X329 transmission_gate_0.vout transmission_gate_1.vctrl r1 VGND sg13_hv_nmos ad=0.38p pd=2.38u as=0.38p ps=2.38u w=2u l=0.45u
X330 hv_mux4_0.nsel4 hv_binary_decoder4_0.msb a_7334_11830# VGND sg13_hv_nmos ad=0.57p pd=3.38u as=1.02p ps=6.68u w=3u l=0.45u
X331 VGND hv_binary_decoder4_0.lsb hv_binary_decoder4_0.hv_nand_0.in2 VGND sg13_hv_nmos ad=0.57p pd=3.38u as=0.57p ps=3.38u w=3u l=0.45u
X332 VAPWR transmission_gate_0.nvctrl transmission_gate_0.vctrl VAPWR sg13_hv_pmos ad=1.9p pd=10.38u as=1.9p ps=10.38u w=10u l=0.4u
X333 a_11274_1983# a_9928_282# VGND VGND sg13_hv_nmos ad=2.04p pd=12.68u as=1.14p ps=6.38u w=6u l=5u
X334 r1 transmission_gate_1.vctrl transmission_gate_0.vout VGND sg13_hv_nmos ad=0.38p pd=2.38u as=0.38p ps=2.38u w=2u l=0.45u
X335 hv_mux4_0.hv_nor4_0.in2 hv_mux4_0.nsel2 VGND VGND sg13_hv_nmos ad=0.57p pd=3.38u as=1.02p ps=6.68u w=3u l=0.45u
X336 a_308_3910# a_172_1840# VGND rsil l=10u w=0.5u
X337 lvl_shift_up_2.hv_inverter_6u5_0.in en VGND VGND sg13_hv_nmos ad=1.9p pd=10.38u as=3.4p ps=20.68u w=10u l=0.45u
X338 a_36_3910# a_36_1840# VGND rsil l=10u w=0.5u
X339 a_9554_8302# ctrl VAPWR VAPWR sg13_hv_pmos ad=1.9p pd=10.38u as=1.9p ps=10.38u w=10u l=0.4u
X340 hv_mux4_0.nsel1 hv_binary_decoder4_0.hv_nand_0.in2 VAPWR VAPWR sg13_hv_pmos ad=1.9p pd=10.38u as=3.4p ps=20.68u w=10u l=0.4u
X341 VAPWR vco_0.bias_current_generator_0.current_reference_40uA_0.iout vco_0.comp_nmos_0.Ibias VAPWR sg13_hv_pmos ad=0.95p pd=5.38u as=0.95p ps=5.38u w=5u l=2u
X342 VAPWR a_11274_1983# a_11274_1983# VAPWR sg13_hv_pmos ad=0.95p pd=5.38u as=0.95p ps=5.38u w=5u l=2u
X343 transmission_gate_0.vout transmission_gate_1.nvctrl r1 VAPWR sg13_hv_pmos ad=0.95p pd=5.38u as=0.95p ps=5.38u w=5u l=0.45u
X344 VAPWR hv_mux4_0.hv_nor_1.out a_13954_8302# VAPWR sg13_hv_pmos ad=1.9p pd=10.38u as=1.9p ps=10.38u w=10u l=0.4u
X345 hv_mux4_0.in1 lvl_shift_up_0.hv_inverter_6u5_0.in VAPWR VAPWR sg13_hv_pmos ad=2.21p pd=13.68u as=2.21p ps=13.68u w=6.5u l=0.4u
X346 VGND selB lvl_shift_up_1.hv_inverter_6u5_0.in VGND sg13_hv_nmos ad=3.4p pd=20.68u as=1.9p ps=10.38u w=10u l=0.45u
X347 transmission_gate_0.vout transmission_gate_0.nvctrl r2 VAPWR sg13_hv_pmos ad=0.95p pd=5.38u as=0.95p ps=5.38u w=5u l=0.45u
X348 a_1668_3910# a_1532_1840# VGND rsil l=10u w=0.5u
X349 r2 transmission_gate_0.nvctrl transmission_gate_0.vout VAPWR sg13_hv_pmos ad=0.95p pd=5.38u as=0.95p ps=5.38u w=5u l=0.45u
X350 transmission_gate_1.vctrl pulse_shaper_en_0.hv_nor$1_0.in1 VGND VGND sg13_hv_nmos ad=0.57p pd=3.38u as=0.57p ps=3.38u w=3u l=0.45u
X351 VGND vco_0.nout a_4364_4622# VGND sg13_hv_nmos ad=0.57p pd=3.38u as=1.02p ps=6.68u w=3u l=0.45u
X352 VGND transmission_gate_1.vctrl transmission_gate_1.nvctrl VGND sg13_hv_nmos ad=0.57p pd=3.38u as=0.57p ps=3.38u w=3u l=0.45u
X353 transmission_gate_0.vout transmission_gate_0.vctrl r2 VGND sg13_hv_nmos ad=0.38p pd=2.38u as=0.38p ps=2.38u w=2u l=0.45u
X354 VGND hv_mux4_0.in2 hv_mux4_0.hv_nor4_0.in2 VGND sg13_hv_nmos ad=1.02p pd=6.68u as=0.57p ps=3.38u w=3u l=0.45u
X355 vco_0.comp_pmos_0.Ibias vco_0.comp_pmos_0.Ibias VAPWR VAPWR sg13_hv_pmos ad=0.68p pd=4.68u as=0.68p ps=4.68u w=2u l=0.4u
X356 transmission_gate_0.vout transmission_gate_0.vctrl r2 VGND sg13_hv_nmos ad=0.38p pd=2.38u as=0.38p ps=2.38u w=2u l=0.45u
X357 transmission_gate_0.vout transmission_gate_1.nvctrl r1 VAPWR sg13_hv_pmos ad=0.95p pd=5.38u as=0.95p ps=5.38u w=5u l=0.45u
X358 ctrl hv_inverter_40u_1.out transmission_gate_2.vout VGND sg13_hv_nmos ad=0.38p pd=2.38u as=0.38p ps=2.38u w=2u l=0.45u
X359 a_1124_3910# a_1260_1840# VGND rsil l=10u w=0.5u
X360 vco_0.nout hv_mux4_0.in2 VAPWR VAPWR sg13_hv_pmos ad=1.9p pd=10.38u as=1.9p ps=10.38u w=10u l=0.4u
X361 a_13934_11830# pulse_shaper_en_0.hv_nand$1_0.in1 transmission_gate_0.nvctrl VGND sg13_hv_nmos ad=0.57p pd=3.38u as=0.57p ps=3.38u w=3u l=0.45u
X362 VAPWR a_11274_1983# a_14530_2070# VAPWR sg13_hv_pmos ad=1.7p pd=10.68u as=0.95p ps=5.38u w=5u l=2u
X363 hv_mux4_0.hv_nor_2.out hv_mux4_0.in3 VGND VGND sg13_hv_nmos ad=0.57p pd=3.38u as=0.57p ps=3.38u w=3u l=0.45u
X364 hv_inverter_40u_0.in hv_mux4_0.hv_nor_1.out VGND VGND sg13_hv_nmos ad=0.57p pd=3.38u as=1.02p ps=6.68u w=3u l=0.45u
X365 VAPWR hv_mux4_0.in2 vco_0.nout VAPWR sg13_hv_pmos ad=1.9p pd=10.38u as=1.9p ps=10.38u w=10u l=0.4u
X366 a_13954_8302# hv_mux4_0.hv_nor_2.out a_12854_8302# VAPWR sg13_hv_pmos ad=3.4p pd=20.68u as=1.9p ps=10.38u w=10u l=0.4u
X367 a_9554_8302# ctrl VAPWR VAPWR sg13_hv_pmos ad=3.4p pd=20.68u as=1.9p ps=10.38u w=10u l=0.4u
X368 lvl_shift_up_1.hv_inverter_6u5_0.in selB VGND VGND sg13_hv_nmos ad=1.9p pd=10.38u as=3.4p ps=20.68u w=10u l=0.45u
X369 hv_mux4_0.nsel1 hv_binary_decoder4_0.hv_nand_0.in1 a_734_11830# VGND sg13_hv_nmos ad=0.57p pd=3.38u as=0.57p ps=3.38u w=3u l=0.45u
X370 transmission_gate_1.vctrl pulse_shaper_en_0.hv_nor$1_0.in1 a_11754_12982# VAPWR sg13_hv_pmos ad=1.9p pd=10.38u as=3.4p ps=20.68u w=10u l=0.4u
X371 VGND hv_mux4_0.nsel3 hv_inverter_40u_1.out VGND sg13_hv_nmos ad=0.57p pd=3.38u as=0.57p ps=3.38u w=3u l=0.45u
X372 a_3028_3910# a_3164_1840# VGND rsil l=10u w=0.5u
X373 a_9116_3986# vco_0.comp_nmos_0.- a_9196_4974# VGND sg13_hv_nmos ad=0.408p pd=3.08u as=0.228p ps=1.58u w=1.2u l=1.5u
X374 a_2756_3910# a_2892_1840# VGND rsil l=10u w=0.5u
X375 r2 transmission_gate_0.vctrl transmission_gate_0.vout VGND sg13_hv_nmos ad=0.38p pd=2.38u as=0.38p ps=2.38u w=2u l=0.45u
X376 a_12854_8302# hv_mux4_0.hv_nor_2.out a_13954_8302# VAPWR sg13_hv_pmos ad=1.9p pd=10.38u as=1.9p ps=10.38u w=10u l=0.4u
X377 transmission_gate_0.vout transmission_gate_1.vctrl r1 VGND sg13_hv_nmos ad=0.38p pd=2.38u as=0.38p ps=2.38u w=2u l=0.45u
X378 VAPWR ctrl a_9554_8302# VAPWR sg13_hv_pmos ad=1.9p pd=10.38u as=1.9p ps=10.38u w=10u l=0.4u
X379 VGND a_242_282# a_242_282# VGND sg13_hv_nmos ad=1.14p pd=6.38u as=2.04p ps=12.68u w=6u l=5u
X380 r1 transmission_gate_1.nvctrl transmission_gate_0.vout VAPWR sg13_hv_pmos ad=0.95p pd=5.38u as=0.95p ps=5.38u w=5u l=0.45u
X381 VAPWR en lvl_shift_up_2.hv_inverter_6u5_0.in VAPWR sg13_hv_pmos ad=0.34p pd=2.68u as=0.19p ps=1.38u w=1u l=0.45u
X382 a_9196_4974# vco_0.vc a_8484_3986# VGND sg13_hv_nmos ad=0.228p pd=1.58u as=0.408p ps=3.08u w=1.2u l=1.5u
X383 VAPWR hv_binary_decoder4_0.msb hv_mux4_0.nsel3 VAPWR sg13_hv_pmos ad=3.4p pd=20.68u as=1.9p ps=10.38u w=10u l=0.4u
X384 a_10258_7890# a_10394_5544# VGND rhigh l=11.3u w=0.5u
X385 pulse_shaper_en_0.hv_nor$1_0.in2 pulse_shaper_en_0.en VAPWR VAPWR sg13_hv_pmos ad=1.9p pd=10.38u as=1.9p ps=10.38u w=10u l=0.4u
X386 transmission_gate_0.vctrl transmission_gate_0.nvctrl VAPWR VAPWR sg13_hv_pmos ad=1.9p pd=10.38u as=3.4p ps=20.68u w=10u l=0.4u
X387 VAPWR hv_binary_decoder4_0.hv_nand_0.in1 hv_mux4_0.nsel1 VAPWR sg13_hv_pmos ad=1.9p pd=10.38u as=1.9p ps=10.38u w=10u l=0.4u
X388 a_2934_11830# hv_binary_decoder4_0.hv_nand_0.in1 hv_mux4_0.nsel2 VGND sg13_hv_nmos ad=0.57p pd=3.38u as=0.57p ps=3.38u w=3u l=0.45u
X389 hv_mux4_0.nsel4 hv_binary_decoder4_0.lsb VAPWR VAPWR sg13_hv_pmos ad=1.9p pd=10.38u as=1.9p ps=10.38u w=10u l=0.4u
X390 VGND hv_binary_decoder4_0.hv_nand_0.in2 a_5134_11830# VGND sg13_hv_nmos ad=0.57p pd=3.38u as=1.02p ps=6.68u w=3u l=0.45u
X391 ctrl hv_mux4_0.nsel3 transmission_gate_2.vout VAPWR sg13_hv_pmos ad=0.95p pd=5.38u as=0.95p ps=5.38u w=5u l=0.45u
X392 transmission_gate_0.vout transmission_gate_1.vctrl r1 VGND sg13_hv_nmos ad=0.38p pd=2.38u as=0.38p ps=2.38u w=2u l=0.45u
X393 VAPWR pulse_shaper_en_0.en pulse_shaper_en_0.hv_nor$1_0.in2 VAPWR sg13_hv_pmos ad=1.9p pd=10.38u as=1.9p ps=10.38u w=10u l=0.4u
X394 hv_mux4_0.hv_nor_0.out hv_mux4_0.in1 VGND VGND sg13_hv_nmos ad=0.57p pd=3.38u as=1.02p ps=6.68u w=3u l=0.45u
X395 transmission_gate_2.vout hv_mux4_0.nsel3 ctrl VAPWR sg13_hv_pmos ad=0.95p pd=5.38u as=0.95p ps=5.38u w=5u l=0.45u
X396 transmission_gate_0.vout transmission_gate_0.nvctrl r2 VAPWR sg13_hv_pmos ad=0.95p pd=5.38u as=0.95p ps=5.38u w=5u l=0.45u
X397 a_4364_4622# vco_0.hv_rs-ff_0.nS hv_mux4_0.in2 VGND sg13_hv_nmos ad=0.57p pd=3.38u as=0.57p ps=3.38u w=3u l=0.45u
X398 VAPWR vco_0.hv_rs-ff_0.nR vco_0.nout VAPWR sg13_hv_pmos ad=3.4p pd=20.68u as=1.9p ps=10.38u w=10u l=0.4u
X399 VAPWR hv_binary_decoder4_0.lsb hv_mux4_0.nsel4 VAPWR sg13_hv_pmos ad=1.9p pd=10.38u as=1.9p ps=10.38u w=10u l=0.4u
X400 VAPWR vco_0.bias_current_generator_0.current_reference_40uA_0.iout a_7372_318# VAPWR sg13_hv_pmos ad=0.95p pd=5.38u as=0.95p ps=5.38u w=5u l=2u
X401 a_2164_4622# vco_0.hv_rs-ff_0.nR VGND VGND sg13_hv_nmos ad=0.57p pd=3.38u as=0.57p ps=3.38u w=3u l=0.45u
X402 VAPWR a_11274_1983# a_11274_1983# VAPWR sg13_hv_pmos ad=0.95p pd=5.38u as=0.95p ps=5.38u w=5u l=2u
X403 transmission_gate_0.vout transmission_gate_0.nvctrl r2 VAPWR sg13_hv_pmos ad=0.95p pd=5.38u as=0.95p ps=5.38u w=5u l=0.45u
X404 a_7334_11830# hv_binary_decoder4_0.msb hv_mux4_0.nsel4 VGND sg13_hv_nmos ad=1.02p pd=6.68u as=0.57p ps=3.38u w=3u l=0.45u
X405 transmission_gate_2.vout hv_mux4_0.nsel3 ctrl VAPWR sg13_hv_pmos ad=0.95p pd=5.38u as=1.7p ps=10.68u w=5u l=0.45u
X406 transmission_gate_2.vout hv_mux4_0.nsel3 ctrl VAPWR sg13_hv_pmos ad=0.95p pd=5.38u as=0.95p ps=5.38u w=5u l=0.45u
X407 VAPWR hv_mux4_0.in3 a_7354_8302# VAPWR sg13_hv_pmos ad=1.9p pd=10.38u as=3.4p ps=20.68u w=10u l=0.4u
X408 VGND hv_mux4_0.nsel2 hv_mux4_0.hv_nor4_0.in2 VGND sg13_hv_nmos ad=1.02p pd=6.68u as=0.57p ps=3.38u w=3u l=0.45u
X409 lvl_shift_up_2.hv_inverter_6u5_0.in en VAPWR VAPWR sg13_hv_pmos ad=0.19p pd=1.38u as=0.34p ps=2.68u w=1u l=0.45u
X410 transmission_gate_0.vctrl transmission_gate_0.nvctrl VGND VGND sg13_hv_nmos ad=0.57p pd=3.38u as=1.02p ps=6.68u w=3u l=0.45u
X411 hv_mux4_0.hv_nor4_0.in2 hv_mux4_0.nsel2 a_5154_8302# VAPWR sg13_hv_pmos ad=1.9p pd=10.38u as=3.4p ps=20.68u w=10u l=0.4u
X412 a_852_3910# a_988_1840# VGND rsil l=10u w=0.5u
X413 VGND a_9928_282# a_9928_282# VGND sg13_hv_nmos ad=1.14p pd=6.38u as=1.14p ps=6.38u w=6u l=5u
X414 a_9928_282# a_9928_282# VGND VGND sg13_hv_nmos ad=1.14p pd=6.38u as=1.14p ps=6.38u w=6u l=5u
X415 VAPWR pulse_shaper_en_0.en transmission_gate_0.nvctrl VAPWR sg13_hv_pmos ad=3.4p pd=20.68u as=1.9p ps=10.38u w=10u l=0.4u
X416 VAPWR a_11274_1983# vco_0.bias_current_generator_0.5uA+ VAPWR sg13_hv_pmos ad=0.95p pd=5.38u as=0.95p ps=5.38u w=5u l=2u
X417 VGND selA lvl_shift_up_3.hv_inverter_6u5_0.in VGND sg13_hv_nmos ad=3.4p pd=20.68u as=1.9p ps=10.38u w=10u l=0.45u
X418 transmission_gate_2.vout hv_mux4_0.nsel3 ctrl VAPWR sg13_hv_pmos ad=0.95p pd=5.38u as=0.95p ps=5.38u w=5u l=0.45u
X419 r1 transmission_gate_1.vctrl transmission_gate_0.vout VGND sg13_hv_nmos ad=0.38p pd=2.38u as=0.38p ps=2.38u w=2u l=0.45u
X420 VGND pulse_shaper_en_0.hv_nor$1_0.in2 transmission_gate_1.vctrl VGND sg13_hv_nmos ad=0.57p pd=3.38u as=0.57p ps=3.38u w=3u l=0.45u
X421 a_1242_318# a_242_282# a_36_1840# VGND sg13_hv_nmos ad=1.14p pd=6.38u as=1.14p ps=6.38u w=6u l=5u
X422 r2 transmission_gate_0.nvctrl transmission_gate_0.vout VAPWR sg13_hv_pmos ad=0.95p pd=5.38u as=0.95p ps=5.38u w=5u l=0.45u
X423 a_580_3910# a_444_1840# VGND rsil l=10u w=0.5u
X424 r1 transmission_gate_1.vctrl transmission_gate_0.vout VGND sg13_hv_nmos ad=0.68p pd=4.68u as=0.38p ps=2.38u w=2u l=0.45u
X425 VGND hv_mux4_0.hv_nor_0.out hv_inverter_40u_0.in VGND sg13_hv_nmos ad=0.57p pd=3.38u as=0.57p ps=3.38u w=3u l=0.45u
X426 a_36_1840# a_242_282# a_1242_318# VGND sg13_hv_nmos ad=1.14p pd=6.38u as=1.14p ps=6.38u w=6u l=5u
X427 hv_mux4_0.hv_nor_2.out hv_mux4_0.nsel3 VGND VGND sg13_hv_nmos ad=0.57p pd=3.38u as=0.57p ps=3.38u w=3u l=0.45u
X428 a_2484_3910# a_2620_1840# VGND rsil l=10u w=0.5u
X429 hv_inverter_40u_0.in hv_mux4_0.hv_nor_2.out VGND VGND sg13_hv_nmos ad=0.57p pd=3.38u as=1.02p ps=6.68u w=3u l=0.45u
X430 VGND a_9928_282# vco_0.voltage_mirror_pmos_0.Ibias VGND sg13_hv_nmos ad=1.14p pd=6.38u as=2.04p ps=12.68u w=6u l=5u
X431 ctrl hv_inverter_40u_1.out transmission_gate_2.vout VGND sg13_hv_nmos ad=0.38p pd=2.38u as=0.38p ps=2.38u w=2u l=0.45u
X432 transmission_gate_2.vout hv_inverter_40u_1.out ctrl VGND sg13_hv_nmos ad=0.38p pd=2.38u as=0.38p ps=2.38u w=2u l=0.45u
X433 a_8830_6546# vco_0.vc a_8648_7374# VAPWR sg13_hv_pmos ad=0.68p pd=4.68u as=0.38p ps=2.38u w=2u l=0.4u
X434 transmission_gate_2.vout hv_inverter_40u_1.out ctrl VGND sg13_hv_nmos ad=0.38p pd=2.38u as=0.38p ps=2.38u w=2u l=0.45u
X435 vco_0.comp_pmos_0.+ a_9986_5544# VGND rhigh l=11.3u w=0.5u
X436 r1 transmission_gate_1.nvctrl transmission_gate_0.vout VAPWR sg13_hv_pmos ad=0.95p pd=5.38u as=0.95p ps=5.38u w=5u l=0.45u
X437 r2 transmission_gate_0.nvctrl transmission_gate_0.vout VAPWR sg13_hv_pmos ad=0.95p pd=5.38u as=0.95p ps=5.38u w=5u l=0.45u
X438 pulse_shaper_en_0.hv_nor$1_0.in1 pulse_shaper_en_0.low_th_inverter_0.vin VGND VGND sg13_hv_nmos ad=0.19p pd=1.38u as=0.34p ps=2.68u w=1u l=0.45u
X439 transmission_gate_0.vout transmission_gate_0.vctrl r2 VGND sg13_hv_nmos ad=0.38p pd=2.38u as=0.38p ps=2.38u w=2u l=0.45u
X440 r1 transmission_gate_1.nvctrl transmission_gate_0.vout VAPWR sg13_hv_pmos ad=0.95p pd=5.38u as=0.95p ps=5.38u w=5u l=0.45u
X441 VGND hv_mux4_0.nsel4 hv_mux4_0.hv_nor_1.out VGND sg13_hv_nmos ad=0.57p pd=3.38u as=0.57p ps=3.38u w=3u l=0.45u
X442 hv_mux4_0.nsel1 hv_binary_decoder4_0.hv_nand_0.in1 VAPWR VAPWR sg13_hv_pmos ad=1.9p pd=10.38u as=3.4p ps=20.68u w=10u l=0.4u
X443 a_7354_8302# hv_mux4_0.nsel3 hv_mux4_0.hv_nor_2.out VAPWR sg13_hv_pmos ad=1.9p pd=10.38u as=1.9p ps=10.38u w=10u l=0.4u
X444 a_2954_8302# hv_mux4_0.in1 VAPWR VAPWR sg13_hv_pmos ad=1.9p pd=10.38u as=1.9p ps=10.38u w=10u l=0.4u
X445 VGND hv_mux4_0.hv_nor_1.out hv_inverter_40u_0.in VGND sg13_hv_nmos ad=1.02p pd=6.68u as=0.57p ps=3.38u w=3u l=0.45u
X446 VAPWR hv_binary_decoder4_0.lsb hv_mux4_0.nsel2 VAPWR sg13_hv_pmos ad=3.4p pd=20.68u as=1.9p ps=10.38u w=10u l=0.4u
X447 transmission_gate_2.vout hv_inverter_40u_1.out ctrl VGND sg13_hv_nmos ad=0.38p pd=2.38u as=0.38p ps=2.38u w=2u l=0.45u
X448 transmission_gate_1.nvctrl transmission_gate_1.vctrl VAPWR VAPWR sg13_hv_pmos ad=1.9p pd=10.38u as=1.9p ps=10.38u w=10u l=0.4u
X449 pulse_shaper_en_0.hv_nor$1_0.in2 pulse_shaper_en_0.en VAPWR VAPWR sg13_hv_pmos ad=1.9p pd=10.38u as=3.4p ps=20.68u w=10u l=0.4u
X450 ctrl hv_inverter_40u_1.out transmission_gate_2.vout VGND sg13_hv_nmos ad=0.68p pd=4.68u as=0.38p ps=2.38u w=2u l=0.45u
X451 a_734_11830# hv_binary_decoder4_0.hv_nand_0.in2 VGND VGND sg13_hv_nmos ad=0.57p pd=3.38u as=0.57p ps=3.38u w=3u l=0.45u
X452 clkout hv_inverter_40u_0.in VPWR VPWR sg13_hv_pmos ad=1.9p pd=10.38u as=1.9p ps=10.38u w=10u l=0.4u
X453 VAPWR selA lvl_shift_up_3.hv_inverter_6u5_0.in VAPWR sg13_hv_pmos ad=0.34p pd=2.68u as=0.19p ps=1.38u w=1u l=0.45u
X454 lvl_shift_up_3.hv_inverter_6u5_0.in selA VGND VGND sg13_hv_nmos ad=1.9p pd=10.38u as=3.4p ps=20.68u w=10u l=0.45u
X455 hv_mux4_0.nsel3 hv_binary_decoder4_0.msb a_5134_11830# VGND sg13_hv_nmos ad=0.57p pd=3.38u as=1.02p ps=6.68u w=3u l=0.45u
X456 hv_mux4_0.nsel4 hv_binary_decoder4_0.msb VAPWR VAPWR sg13_hv_pmos ad=1.9p pd=10.38u as=1.9p ps=10.38u w=10u l=0.4u
X457 hv_mux4_0.nsel4 hv_binary_decoder4_0.lsb VAPWR VAPWR sg13_hv_pmos ad=1.9p pd=10.38u as=3.4p ps=20.68u w=10u l=0.4u
X458 VGND a_7372_318# a_7372_318# VGND sg13_hv_nmos ad=1.14p pd=6.38u as=2.04p ps=12.68u w=6u l=5u
X459 vco_0.nout hv_mux4_0.in2 a_2164_4622# VGND sg13_hv_nmos ad=0.57p pd=3.38u as=0.57p ps=3.38u w=3u l=0.45u
X460 VAPWR transmission_gate_1.vctrl transmission_gate_1.nvctrl VAPWR sg13_hv_pmos ad=1.9p pd=10.38u as=1.9p ps=10.38u w=10u l=0.4u
X461 transmission_gate_0.vout transmission_gate_1.vctrl r1 VGND sg13_hv_nmos ad=0.38p pd=2.38u as=0.38p ps=2.38u w=2u l=0.45u
X462 hv_mux4_0.hv_nor_0.out hv_mux4_0.nsel1 VGND VGND sg13_hv_nmos ad=0.57p pd=3.38u as=1.02p ps=6.68u w=3u l=0.45u
X463 lvl_shift_up_0.hv_inverter_6u5_0.in clkin VAPWR VAPWR sg13_hv_pmos ad=0.19p pd=1.38u as=0.34p ps=2.68u w=1u l=0.45u
X464 VAPWR hv_binary_decoder4_0.msb hv_mux4_0.nsel4 VAPWR sg13_hv_pmos ad=1.9p pd=10.38u as=1.9p ps=10.38u w=10u l=0.4u
X465 a_10052_3986# vco_0.voltage_mirror_pmos_0.Ibias VAPWR VAPWR sg13_hv_pmos ad=3.4p pd=20.68u as=1.9p ps=10.38u w=10u l=2u
X466 VAPWR hv_binary_decoder4_0.msb hv_binary_decoder4_0.hv_nand_0.in1 VAPWR sg13_hv_pmos ad=1.9p pd=10.38u as=1.9p ps=10.38u w=10u l=0.4u
X467 lvl_shift_up_0.hv_inverter_6u5_0.in clkin VGND VGND sg13_hv_nmos ad=1.9p pd=10.38u as=3.4p ps=20.68u w=10u l=0.45u
X468 a_580_3910# a_716_1840# VGND rsil l=10u w=0.5u
X469 a_5134_11830# hv_binary_decoder4_0.hv_nand_0.in2 VGND VGND sg13_hv_nmos ad=1.02p pd=6.68u as=0.57p ps=3.38u w=3u l=0.45u
X470 VAPWR vco_0.comp_pmos_0.Ibias vco_0.hv_inverter_6u5$2_0.in VAPWR sg13_hv_pmos ad=0.38p pd=2.38u as=0.68p ps=4.68u w=2u l=0.4u
X471 r2 transmission_gate_0.vctrl transmission_gate_0.vout VGND sg13_hv_nmos ad=0.38p pd=2.38u as=0.38p ps=2.38u w=2u l=0.45u
X472 hv_mux4_0.in2 vco_0.nout VAPWR VAPWR sg13_hv_pmos ad=1.9p pd=10.38u as=3.4p ps=20.68u w=10u l=0.4u
X473 a_5154_8302# hv_mux4_0.in2 VAPWR VAPWR sg13_hv_pmos ad=3.4p pd=20.68u as=1.9p ps=10.38u w=10u l=0.4u
X474 VGND hv_mux4_0.in1 hv_mux4_0.hv_nor_0.out VGND sg13_hv_nmos ad=1.02p pd=6.68u as=0.57p ps=3.38u w=3u l=0.45u
X475 pulse_shaper_en_0.hv_nor$1_0.in2 pulse_shaper_en_0.en VGND VGND sg13_hv_nmos ad=0.57p pd=3.38u as=1.02p ps=6.68u w=3u l=0.45u
X476 a_2212_3910# a_2348_1840# VGND rsil l=10u w=0.5u
X477 a_242_282# a_1242_318# VAPWR VAPWR sg13_hv_pmos ad=3.4p pd=20.68u as=1.9p ps=10.38u w=10u l=2u
X478 a_2954_8302# hv_mux4_0.nsel1 hv_mux4_0.hv_nor_0.out VAPWR sg13_hv_pmos ad=3.4p pd=20.68u as=1.9p ps=10.38u w=10u l=0.4u
X479 hv_inverter_40u_1.out hv_mux4_0.nsel3 VAPWR VAPWR sg13_hv_pmos ad=1.9p pd=10.38u as=1.9p ps=10.38u w=10u l=0.4u
X480 VAPWR selB lvl_shift_up_1.hv_inverter_6u5_0.in VAPWR sg13_hv_pmos ad=0.34p pd=2.68u as=0.19p ps=1.38u w=1u l=0.45u
X481 VAPWR pulse_shaper_en_0.hv_nand$1_0.in1 transmission_gate_0.nvctrl VAPWR sg13_hv_pmos ad=3.4p pd=20.68u as=1.9p ps=10.38u w=10u l=0.4u
X482 hv_mux4_0.hv_nor_1.out hv_mux4_0.nsel4 a_9554_8302# VAPWR sg13_hv_pmos ad=1.9p pd=10.38u as=1.9p ps=10.38u w=10u l=0.4u
X483 VAPWR hv_mux4_0.in2 a_5154_8302# VAPWR sg13_hv_pmos ad=1.9p pd=10.38u as=1.9p ps=10.38u w=10u l=0.4u
X484 lvl_shift_up_3.hv_inverter_6u5_0.in selA VAPWR VAPWR sg13_hv_pmos ad=0.19p pd=1.38u as=0.34p ps=2.68u w=1u l=0.45u
X485 hv_mux4_0.hv_nor_0.out hv_mux4_0.nsel1 a_2954_8302# VAPWR sg13_hv_pmos ad=1.9p pd=10.38u as=1.9p ps=10.38u w=10u l=0.4u
X486 VAPWR hv_mux4_0.nsel3 hv_inverter_40u_1.out VAPWR sg13_hv_pmos ad=1.9p pd=10.38u as=1.9p ps=10.38u w=10u l=0.4u
X487 VAPWR vco_0.hv_inverter_6u5$2_0.in vco_0.hv_rs-ff_0.nR VAPWR sg13_hv_pmos ad=2.21p pd=13.68u as=2.21p ps=13.68u w=6.5u l=0.4u
X488 VGND hv_binary_decoder4_0.lsb a_7334_11830# VGND sg13_hv_nmos ad=0.57p pd=3.38u as=0.57p ps=3.38u w=3u l=0.45u
X489 ctrl hv_mux4_0.nsel3 transmission_gate_2.vout VAPWR sg13_hv_pmos ad=0.95p pd=5.38u as=0.95p ps=5.38u w=5u l=0.45u
X490 transmission_gate_0.vout transmission_gate_0.nvctrl r2 VAPWR sg13_hv_pmos ad=0.95p pd=5.38u as=0.95p ps=5.38u w=5u l=0.45u
X491 VGND pulse_shaper_en_0.en a_13934_11830# VGND sg13_hv_nmos ad=0.57p pd=3.38u as=1.02p ps=6.68u w=3u l=0.45u
X492 VGND ctrl hv_mux4_0.hv_nor_1.out VGND sg13_hv_nmos ad=0.57p pd=3.38u as=0.57p ps=3.38u w=3u l=0.45u
X493 VAPWR ctrl a_9554_8302# VAPWR sg13_hv_pmos ad=1.9p pd=10.38u as=3.4p ps=20.68u w=10u l=0.4u
X494 hv_mux4_0.hv_nor4_0.in2 hv_mux4_0.in2 VGND VGND sg13_hv_nmos ad=0.57p pd=3.38u as=0.57p ps=3.38u w=3u l=0.45u
X495 VGND transmission_gate_0.nvctrl transmission_gate_0.vctrl VGND sg13_hv_nmos ad=1.02p pd=6.68u as=0.57p ps=3.38u w=3u l=0.45u
X496 a_13954_8302# hv_mux4_0.hv_nor_1.out VAPWR VAPWR sg13_hv_pmos ad=1.9p pd=10.38u as=3.4p ps=20.68u w=10u l=0.4u
X497 vco_0.voltage_mirror_pmos_0.Ibias vco_0.voltage_mirror_pmos_0.Ibias VAPWR VAPWR sg13_hv_pmos ad=1.805p pd=9.88u as=3.23p ps=19.68u w=9.5u l=2u
X498 VGND hv_binary_decoder4_0.msb hv_binary_decoder4_0.hv_nand_0.in1 VGND sg13_hv_nmos ad=0.57p pd=3.38u as=0.57p ps=3.38u w=3u l=0.45u
X499 VGND vco_0.comp_nmos_0.Ibias vco_0.comp_nmos_0.out VGND sg13_hv_nmos ad=0.456p pd=2.78u as=0.816p ps=5.48u w=2.4u l=1.5u
X500 VGND hv_mux4_0.in3 hv_mux4_0.hv_nor_2.out VGND sg13_hv_nmos ad=0.57p pd=3.38u as=0.57p ps=3.38u w=3u l=0.45u
X501 r1 transmission_gate_1.nvctrl transmission_gate_0.vout VAPWR sg13_hv_pmos ad=0.95p pd=5.38u as=0.95p ps=5.38u w=5u l=0.45u
X502 a_3572_3910# a_3436_1840# VGND rsil l=10u w=0.5u
X503 VGND hv_mux4_0.hv_nor_2.out hv_inverter_40u_0.in VGND sg13_hv_nmos ad=1.02p pd=6.68u as=0.57p ps=3.38u w=3u l=0.45u
X504 VAPWR hv_binary_decoder4_0.hv_nand_0.in1 hv_mux4_0.nsel2 VAPWR sg13_hv_pmos ad=3.4p pd=20.68u as=1.9p ps=10.38u w=10u l=0.4u
X505 a_4364_4622# vco_0.nout VGND VGND sg13_hv_nmos ad=1.02p pd=6.68u as=0.57p ps=3.38u w=3u l=0.45u
X506 lvl_shift_up_1.hv_inverter_6u5_0.in selB VAPWR VAPWR sg13_hv_pmos ad=0.19p pd=1.38u as=0.34p ps=2.68u w=1u l=0.45u
X507 a_4364_4622# vco_0.hv_rs-ff_0.nS hv_mux4_0.in2 VGND sg13_hv_nmos ad=1.02p pd=6.68u as=0.57p ps=3.38u w=3u l=0.45u
X508 a_8830_6546# a_8830_6546# VGND VGND sg13_hv_nmos ad=0.408p pd=3.08u as=0.228p ps=1.58u w=1.2u l=1.5u
X509 ctrl hv_inverter_40u_1.out transmission_gate_2.vout VGND sg13_hv_nmos ad=0.38p pd=2.38u as=0.38p ps=2.38u w=2u l=0.45u
X510 VGND hv_binary_decoder4_0.lsb a_2934_11830# VGND sg13_hv_nmos ad=0.57p pd=3.38u as=1.02p ps=6.68u w=3u l=0.45u
X511 hv_mux4_0.nsel3 hv_binary_decoder4_0.hv_nand_0.in2 VAPWR VAPWR sg13_hv_pmos ad=1.9p pd=10.38u as=1.9p ps=10.38u w=10u l=0.4u
X512 hv_mux4_0.nsel4 hv_binary_decoder4_0.msb VAPWR VAPWR sg13_hv_pmos ad=1.9p pd=10.38u as=3.4p ps=20.68u w=10u l=0.4u
X513 VAPWR hv_binary_decoder4_0.hv_nand_0.in2 hv_mux4_0.nsel3 VAPWR sg13_hv_pmos ad=1.9p pd=10.38u as=1.9p ps=10.38u w=10u l=0.4u
X514 a_13954_8302# hv_mux4_0.hv_nor_2.out a_12854_8302# VAPWR sg13_hv_pmos ad=1.9p pd=10.38u as=1.9p ps=10.38u w=10u l=0.4u
X515 ctrl hv_inverter_40u_1.out transmission_gate_2.vout VGND sg13_hv_nmos ad=0.38p pd=2.38u as=0.38p ps=2.38u w=2u l=0.45u
X516 VGND hv_inverter_40u_0.in clkout VGND sg13_hv_nmos ad=0.57p pd=3.38u as=0.57p ps=3.38u w=3u l=0.45u
X517 a_1668_3910# a_1804_1840# VGND rsil l=10u w=0.5u
X518 vco_0.nout hv_mux4_0.in2 a_2164_4622# VGND sg13_hv_nmos ad=0.57p pd=3.38u as=1.02p ps=6.68u w=3u l=0.45u
X519 a_5134_11830# hv_binary_decoder4_0.msb hv_mux4_0.nsel3 VGND sg13_hv_nmos ad=1.02p pd=6.68u as=0.57p ps=3.38u w=3u l=0.45u
X520 a_1396_3910# a_1260_1840# VGND rsil l=10u w=0.5u
X521 vco_0.vc hv_mux4_0.in2 vco_0.bias_current_generator_0.5uA- VGND sg13_hv_nmos ad=0.102p pd=1.28u as=0.102p ps=1.28u w=0.3u l=0.45u
X522 transmission_gate_0.vout transmission_gate_0.vctrl r2 VGND sg13_hv_nmos ad=0.38p pd=2.38u as=0.38p ps=2.38u w=2u l=0.45u
X523 r2 transmission_gate_0.nvctrl transmission_gate_0.vout VAPWR sg13_hv_pmos ad=1.7p pd=10.68u as=0.95p ps=5.38u w=5u l=0.45u
X524 VGND hv_mux4_0.nsel1 hv_mux4_0.hv_nor_0.out VGND sg13_hv_nmos ad=1.02p pd=6.68u as=0.57p ps=3.38u w=3u l=0.45u
X525 transmission_gate_0.vout transmission_gate_1.nvctrl r1 VAPWR sg13_hv_pmos ad=0.95p pd=5.38u as=0.95p ps=5.38u w=5u l=0.45u
X526 a_9850_7890# VGND VGND rhigh l=11.3u w=0.5u
X527 vco_0.bias_current_generator_0.current_reference_40uA_0.iout a_242_282# VGND VGND sg13_hv_nmos ad=2.04p pd=12.68u as=1.14p ps=6.38u w=6u l=5u
X528 hv_mux4_0.in2 vco_0.hv_rs-ff_0.nS VAPWR VAPWR sg13_hv_pmos ad=1.9p pd=10.38u as=1.9p ps=10.38u w=10u l=0.4u
X529 a_11754_12982# pulse_shaper_en_0.hv_nor$1_0.in2 VAPWR VAPWR sg13_hv_pmos ad=3.4p pd=20.68u as=1.9p ps=10.38u w=10u l=0.4u
X530 vco_0.nout vco_0.hv_rs-ff_0.nR VAPWR VAPWR sg13_hv_pmos ad=1.9p pd=10.38u as=1.9p ps=10.38u w=10u l=0.4u
X531 transmission_gate_2.vout hv_inverter_40u_1.out ctrl VGND sg13_hv_nmos ad=0.38p pd=2.38u as=0.38p ps=2.38u w=2u l=0.45u
X532 a_12880_5408# ctrl VGND rhigh l=6.78u w=0.5u
X533 a_12608_5408# a_12744_3966# VGND rhigh l=6.78u w=0.5u
X534 VGND lvl_shift_up_2.hv_inverter_6u5_0.in pulse_shaper_en_0.en VGND sg13_hv_nmos ad=0.68p pd=4.68u as=0.68p ps=4.68u w=2u l=0.45u
X535 transmission_gate_0.vout transmission_gate_1.vctrl r1 VGND sg13_hv_nmos ad=0.38p pd=2.38u as=0.38p ps=2.38u w=2u l=0.45u
X536 VGND pulse_shaper_en_0.hv_nor$1_0.in1 transmission_gate_1.vctrl VGND sg13_hv_nmos ad=0.57p pd=3.38u as=0.57p ps=3.38u w=3u l=0.45u
X537 hv_mux4_0.nsel4 hv_binary_decoder4_0.msb a_7334_11830# VGND sg13_hv_nmos ad=0.57p pd=3.38u as=0.57p ps=3.38u w=3u l=0.45u
X538 a_3572_3910# a_3708_1840# VGND rsil l=10u w=0.5u
X539 ctrl hv_mux4_0.nsel3 transmission_gate_2.vout VAPWR sg13_hv_pmos ad=0.95p pd=5.38u as=0.95p ps=5.38u w=5u l=0.45u
X540 transmission_gate_0.nvctrl pulse_shaper_en_0.hv_nand$1_0.in1 a_13934_11830# VGND sg13_hv_nmos ad=0.57p pd=3.38u as=1.02p ps=6.68u w=3u l=0.45u
X541 VAPWR vco_0.hv_rs-ff_0.nS hv_mux4_0.in2 VAPWR sg13_hv_pmos ad=1.9p pd=10.38u as=1.9p ps=10.38u w=10u l=0.4u
X542 VAPWR vco_0.hv_rs-ff_0.nR vco_0.nout VAPWR sg13_hv_pmos ad=1.9p pd=10.38u as=1.9p ps=10.38u w=10u l=0.4u
X543 hv_mux4_0.hv_nor4_0.in2 hv_mux4_0.nsel2 VGND VGND sg13_hv_nmos ad=0.57p pd=3.38u as=0.57p ps=3.38u w=3u l=0.45u
X544 hv_inverter_40u_0.in hv_mux4_0.hv_nor4_0.in2 VGND VGND sg13_hv_nmos ad=0.57p pd=3.38u as=1.02p ps=6.68u w=3u l=0.45u
X545 VGND pulse_shaper_en_0.en pulse_shaper_en_0.hv_nor$1_0.in2 VGND sg13_hv_nmos ad=1.02p pd=6.68u as=0.57p ps=3.38u w=3u l=0.45u
X546 a_12854_8302# hv_mux4_0.hv_nor4_0.in2 a_11754_8302# VAPWR sg13_hv_pmos ad=3.4p pd=20.68u as=1.9p ps=10.38u w=10u l=0.4u
X547 a_9554_8302# hv_mux4_0.nsel4 hv_mux4_0.hv_nor_1.out VAPWR sg13_hv_pmos ad=3.4p pd=20.68u as=1.9p ps=10.38u w=10u l=0.4u
X548 hv_mux4_0.in3 osc_0.c2 VGND VGND sg13_hv_nmos ad=1.02p pd=6.68u as=0.57p ps=3.38u w=3u l=0.45u
X549 a_3300_3910# a_3164_1840# VGND rsil l=10u w=0.5u
C0 clkout VGND 29.53921f
C1 r2 VGND 37.88957f
C2 r1 VGND 35.53887f
C3 ctrl VGND 0.45016f
C4 VPWR VGND 18.4046f
C5 VAPWR VGND 0.40354p
C6 vco_0.bias_current_generator_0.5uA- VGND 1.48947f
C7 vco_0.bias_current_generator_0.5uA+ VGND 2.76812f
C8 a_12880_5408# VGND 1.18f
C9 a_12744_3966# VGND 1.18f
C10 a_12608_5408# VGND 1.18f
C11 a_12472_3966# VGND 1.18f
C12 a_9116_3986# VGND 4.41855f
C13 a_8484_3986# VGND 0.1633p
C14 a_4252_1840# VGND 2.72973f
C15 a_4116_3910# VGND 1.58633f
C16 a_3980_1840# VGND 1.58633f
C17 a_3844_3910# VGND 1.58633f
C18 a_3708_1840# VGND 1.58633f
C19 a_3572_3910# VGND 1.58633f
C20 a_3436_1840# VGND 1.58633f
C21 a_3300_3910# VGND 1.58633f
C22 a_3164_1840# VGND 1.58633f
C23 a_3028_3910# VGND 1.58633f
C24 a_2892_1840# VGND 1.58633f
C25 a_2756_3910# VGND 1.58633f
C26 a_2620_1840# VGND 1.58633f
C27 a_2484_3910# VGND 1.58633f
C28 a_2348_1840# VGND 1.58633f
C29 a_2212_3910# VGND 1.58633f
C30 a_2076_1840# VGND 1.58633f
C31 a_1940_3910# VGND 1.58633f
C32 a_1804_1840# VGND 1.58633f
C33 a_1668_3910# VGND 1.58633f
C34 a_1532_1840# VGND 1.58633f
C35 a_1396_3910# VGND 1.58633f
C36 a_1260_1840# VGND 1.58633f
C37 a_1124_3910# VGND 1.58633f
C38 a_988_1840# VGND 1.58633f
C39 a_852_3910# VGND 1.58633f
C40 a_716_1840# VGND 1.58633f
C41 a_580_3910# VGND 1.58633f
C42 a_444_1840# VGND 1.58633f
C43 a_308_3910# VGND 1.58633f
C44 a_172_1840# VGND 1.58633f
C45 a_36_1840# VGND 19.25562f
C46 a_36_3910# VGND 1.58633f
C47 a_4588_4120# VGND 3.68942f
C48 a_10052_3986# VGND 0.22508f
C49 a_10394_5544# VGND 1.78021f
C50 a_10258_7890# VGND 1.78021f
C51 a_9986_5544# VGND 1.78021f
C52 a_4364_4622# VGND 5.86112f
C53 a_2164_4622# VGND 8.46041f
C54 a_9196_4974# VGND 0.16898p
C55 a_9850_7890# VGND 1.78021f
C56 a_8648_7374# VGND 9.96323f
C57 vco_0.comp_pmos_0.+ VGND 8.41892f
C58 transmission_gate_0.vout VGND 0.97972p
C59 a_13954_8302# VGND 9.7666f
C60 a_12854_8302# VGND 22.04137f
C61 a_11754_8302# VGND 22.48746f
C62 a_9554_8302# VGND 17.1946f
C63 a_7354_8302# VGND 29.63295f
C64 a_5154_8302# VGND 40.54279f
C65 a_2954_8302# VGND 27.5447f
C66 a_13934_11830# VGND 14.01122f
C67 a_7334_11830# VGND 4.30424f
C68 a_5134_11830# VGND 8.55682f
C69 a_2934_11830# VGND 11.83882f
C70 a_734_11830# VGND 3.89028f
C71 a_11754_12982# VGND 14.30624f
C72 osc_0.out2 VGND 18.7051f
C73 pulse_shaper_en_0.hv_nor$1_0.in2 VGND 0.2528f
C74 lvl_shift_up_1.hv_inverter_6u5_0.in VGND 1.01118f
C75 lvl_shift_up_3.hv_inverter_6u5_0.in VGND 1.01118f

C76 osc_0.c1 hv_mux4_0.in3 53f
C77 osc_0.c2 osc_0.out2 53f
C78 vco_0.vc VGND 940.4f
C79 transmission_gate_0.vout VGND 2.7548p

.ends
