* PEX produced on Mo 14. Sep 17:19:51 CEST 2026 using scripts/sak-pex.sh with m=3 and s=1 (extresist threshold=10000 mOhm, minres=1000 mOhm, mindelay=1 ps)
* NGSPICE file created from hv_inverter_40u_pex.ext - technology: ihp-sg13cmos5l

.subckt hv_inverter_40u_pex VDD in out VSS
X0 VSS in out VSS.t1 sg13_hv_nmos ad=0.57p pd=3.38u as=0.57p ps=3.38u w=3u l=0.45u
X1 out in VDD VDD sg13_hv_pmos ad=1.9p pd=10.38u as=1.9p ps=10.38u w=10u l=0.4u
X2 VDD in out VDD sg13_hv_pmos ad=3.4p pd=20.68u as=1.9p ps=10.38u w=10u l=0.4u
X3 VSS in out VSS.t3 sg13_hv_nmos ad=1.02p pd=6.68u as=0.57p ps=3.38u w=3u l=0.45u
X4 out in VDD VDD sg13_hv_pmos ad=1.9p pd=10.38u as=3.4p ps=20.68u w=10u l=0.4u
X5 out in VSS VSS.t2 sg13_hv_nmos ad=0.57p pd=3.38u as=0.57p ps=3.38u w=3u l=0.45u
X6 out in VSS VSS.t0 sg13_hv_nmos ad=0.57p pd=3.38u as=1.02p ps=6.68u w=3u l=0.45u
X7 VDD in out VDD sg13_hv_pmos ad=1.9p pd=10.38u as=1.9p ps=10.38u w=10u l=0.4u
R0 VSS.t1 VSS.n4 289.19
R1 VSS.n4 VSS.t2 159.459
R2 VSS.n2 VSS.t0 43.8375
R3 VSS.n2 VSS.t1 32.4557
R4 VSS.t2 VSS.n3 32.4557
R5 VSS.n2 VSS.n1 0.011342
R6 VSS.n1 VSS.n4 8.50151
R7 VSS.t3 VSS.n3 43.8379
R8 VSS VSS.n1 1.66003
R9 VSS.n0 VSS.n1 0.0980738
R10 VSS.n1 VSS.n3 0.011335
R11 VSS VSS.n0 1.20618
R12 VSS VSS.n0 1.19466
C0 VDD out 4.58759f
C1 out in 2.24491f
C2 VDD in 3.5048f
C3 out VSS 3.69054f
C4 VDD VSS 1.10335f
.ends
