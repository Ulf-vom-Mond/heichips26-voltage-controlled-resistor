* PEX produced on Mi 9. Sep 15:40:49 CEST 2026 using scripts/sak-pex.sh with m=3 and s=1 (extresist threshold=10000 mOhm, minres=1000 mOhm, mindelay=1 ps)
* NGSPICE file created from hv_rs-ff_pex.ext - technology: ihp-sg13cmos5l

.subckt hv_rs-ff_pex VDD nS Q nQ nR VSS
X0 VDD nR nQ VDD sg13_hv_pmos ad=3.4p pd=20.68u as=1.9p ps=10.38u w=10u l=0.4u
X1 a_n362_n876# nQ VSS.t7 VSS.t8 sg13_hv_nmos ad=0.57p pd=3.38u as=0.57p ps=3.38u w=3u l=0.45u
X2 VDD nQ Q VDD sg13_hv_pmos ad=3.4p pd=20.68u as=1.9p ps=10.38u w=10u l=0.4u
X3 nQ Q VDD VDD sg13_hv_pmos ad=1.9p pd=10.38u as=1.9p ps=10.38u w=10u l=0.4u
X4 a_n362_n876# nS Q VSS.t15 sg13_hv_nmos ad=0.57p pd=3.38u as=0.57p ps=3.38u w=3u l=0.45u
X5 nQ Q VDD VDD sg13_hv_pmos ad=1.9p pd=10.38u as=3.4p ps=20.68u w=10u l=0.4u
X6 VSS.t4 nQ a_n362_n876# VSS.t9 sg13_hv_nmos ad=0.57p pd=3.38u as=0.57p ps=3.38u w=3u l=0.45u
X7 Q nS VDD VDD sg13_hv_pmos ad=1.9p pd=10.38u as=1.9p ps=10.38u w=10u l=0.4u
X8 a_1838_n876# Q nQ VSS.t14 sg13_hv_nmos ad=1.02p pd=6.68u as=0.57p ps=3.38u w=3u l=0.45u
X9 VDD nS Q VDD sg13_hv_pmos ad=3.4p pd=20.68u as=1.9p ps=10.38u w=10u l=0.4u
X10 a_n362_n876# nS Q VSS.t17 sg13_hv_nmos ad=1.02p pd=6.68u as=0.57p ps=3.38u w=3u l=0.45u
X11 Q nQ VDD VDD sg13_hv_pmos ad=1.9p pd=10.38u as=3.4p ps=20.68u w=10u l=0.4u
X12 VDD Q nQ VDD sg13_hv_pmos ad=1.9p pd=10.38u as=1.9p ps=10.38u w=10u l=0.4u
X13 nQ nR VDD VDD sg13_hv_pmos ad=1.9p pd=10.38u as=3.4p ps=20.68u w=10u l=0.4u
X14 VSS.t7 nQ a_n362_n876# VSS.t6 sg13_hv_nmos ad=0.57p pd=3.38u as=1.02p ps=6.68u w=3u l=0.45u
X15 a_1838_n876# nR VSS.t1 VSS.t2 sg13_hv_nmos ad=0.57p pd=3.38u as=0.57p ps=3.38u w=3u l=0.45u
X16 Q nS VDD VDD sg13_hv_pmos ad=1.9p pd=10.38u as=3.4p ps=20.68u w=10u l=0.4u
X17 VSS.t4 nR a_1838_n876# VSS.t3 sg13_hv_nmos ad=0.57p pd=3.38u as=0.57p ps=3.38u w=3u l=0.45u
X18 Q nS a_n362_n876# VSS.t16 sg13_hv_nmos ad=0.57p pd=3.38u as=0.57p ps=3.38u w=3u l=0.45u
X19 VDD Q nQ VDD sg13_hv_pmos ad=3.4p pd=20.68u as=1.9p ps=10.38u w=10u l=0.4u
X20 nQ nR VDD VDD sg13_hv_pmos ad=1.9p pd=10.38u as=1.9p ps=10.38u w=10u l=0.4u
X21 a_n362_n876# nQ VSS.t4 VSS.t10 sg13_hv_nmos ad=1.02p pd=6.68u as=0.57p ps=3.38u w=3u l=0.45u
X22 Q nQ VDD VDD sg13_hv_pmos ad=1.9p pd=10.38u as=1.9p ps=10.38u w=10u l=0.4u
X23 nQ Q a_1838_n876# VSS.t11 sg13_hv_nmos ad=0.57p pd=3.38u as=1.02p ps=6.68u w=3u l=0.45u
X24 a_1838_n876# Q nQ VSS.t12 sg13_hv_nmos ad=0.57p pd=3.38u as=0.57p ps=3.38u w=3u l=0.45u
X25 VSS.t1 nR a_1838_n876# VSS.t0 sg13_hv_nmos ad=0.57p pd=3.38u as=1.02p ps=6.68u w=3u l=0.45u
X26 Q nS a_n362_n876# VSS.t4 sg13_hv_nmos ad=0.57p pd=3.38u as=1.02p ps=6.68u w=3u l=0.45u
X27 VDD nQ Q VDD sg13_hv_pmos ad=1.9p pd=10.38u as=1.9p ps=10.38u w=10u l=0.4u
X28 VDD nR nQ VDD sg13_hv_pmos ad=1.9p pd=10.38u as=1.9p ps=10.38u w=10u l=0.4u
X29 nQ Q a_1838_n876# VSS.t13 sg13_hv_nmos ad=0.57p pd=3.38u as=0.57p ps=3.38u w=3u l=0.45u
X30 VDD nS Q VDD sg13_hv_pmos ad=1.9p pd=10.38u as=1.9p ps=10.38u w=10u l=0.4u
X31 a_1838_n876# nR VSS.t4 VSS.t5 sg13_hv_nmos ad=1.02p pd=6.68u as=0.57p ps=3.38u w=3u l=0.45u
R0 VSS.t4 VSS.t8 29.1282
R1 VSS.t15 VSS.t4 29.1295
R2 VSS.t4 VSS.t13 27.0604
R3 VSS.t4 VSS.t2 29.1272
R4 VSS.t4 VSS.t6 43.8369
R5 VSS.t14 VSS.t4 43.8368
R6 VSS.t4 VSS.t17 43.8374
R7 VSS.t4 VSS.t5 43.8368
R8 VSS.t11 VSS.t4 43.8369
R9 VSS.t4 VSS.t0 43.8374
R10 VSS.t4 VSS.t10 43.8367
R11 VSS VSS.t4 1.32905
R12 VSS.t1 VSS.t4 0.544624
R13 VSS.t4 VSS.t16 27.0588
R14 VSS.t4 VSS.t9 27.0593
R15 VSS.t4 VSS.t3 27.0604
R16 VSS.t4 VSS.t12 29.1272
R17 VSS.t4 VSS.t7 1.31138
C0 Q nR 0.02715f
C1 a_1838_n876# Q 1.36749f
C2 Q nQ 6.89425f
C3 nS Q 3.76936f
C4 VDD Q 20.2057f
C5 a_1838_n876# nR 0.77997f
C6 nR nQ 2.17571f
C7 a_n362_n876# Q 2.8369f
C8 a_1838_n876# nQ 2.76635f
C9 nS nQ 0.02715f
C10 VDD nR 4.00155f
C11 VDD nQ 20.3181f
C12 a_1838_n876# a_n362_n876# 0.16685f
C13 a_n362_n876# nQ 0.76092f
C14 nS VDD 3.88963f
C15 a_n362_n876# nS 1.36749f
C16 VDD VSS 4.99556f
C17 a_1838_n876# VSS 5.00169f
C18 a_n362_n876# VSS 9.68862f
C19 VSS.t4 VSS 1.00799f
C20 VSS.t7 VSS 2.63722f
.ends
