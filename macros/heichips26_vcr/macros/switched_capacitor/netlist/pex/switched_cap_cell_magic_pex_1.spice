* PEX produced on Fr 18. Sep 21:53:41 CEST 2026 using scripts/sak-pex.sh with m=1 and s=1
* NGSPICE file created from switched_cap_cell_pex.ext - technology: ihp-sg13cmos5l

.subckt switched_cap_cell_pex ctrl VAPWR VGND r2 r1 clkin selA selB en VPWR
+ clkout
X0 a_760_11830# hv_binary_decoder4_0.hv_nand_0.in2 VGND VGND sg13_hv_nmos ad=1.02p pd=6.68u as=0.57p ps=3.38u w=3u l=0.45u
X1 a_4142_3910# a_4278_1840# VGND rsil l=10u w=0.5u
X2 transmission_gate_1.vout transmission_gate_1.nvctrl r1 VAPWR sg13_hv_pmos ad=0.95p pd=5.38u as=0.95p ps=5.38u w=5u l=0.45u
X3 pulse_shaper_en_0.hv_nand$1_0.in1 pulse_shaper_en_0.low_th_inverter_0.vin VGND VGND sg13_hv_nmos ad=0.19p pd=1.38u as=0.34p ps=2.68u w=1u l=0.45u
X4 VGND hv_binary_decoder4_0.hv_nand_0.in2 a_760_11830# VGND sg13_hv_nmos ad=0.57p pd=3.38u as=0.57p ps=3.38u w=3u l=0.45u
X5 VAPWR lvl_shift_up_2.hv_inverter_6u5_0.in pulse_shaper_en_0.en VAPWR sg13_hv_pmos ad=2.21p pd=13.68u as=2.21p ps=13.68u w=6.5u l=0.4u
X6 pulse_shaper_en_0.hv_nor$1_0.in1 pulse_shaper_en_0.low_th_inverter_0.vin VAPWR VAPWR sg13_hv_pmos ad=1.9p pd=10.38u as=3.4p ps=20.68u w=10u l=0.4u
X7 transmission_gate_2.vout hv_mux4_0.nsel3 ctrl VAPWR sg13_hv_pmos ad=0.95p pd=5.38u as=0.95p ps=5.38u w=5u l=0.45u
X8 a_9954_282# vco_0.bias_current_generator$1_0.current_reference_40uA$1_0.iout VAPWR VAPWR sg13_hv_pmos ad=0.95p pd=5.38u as=0.95p ps=5.38u w=5u l=2u
X9 VAPWR clkin lvl_shift_up_0.hv_inverter_6u5_0.in VAPWR sg13_hv_pmos ad=0.34p pd=2.68u as=0.19p ps=1.38u w=1u l=0.45u
X10 a_11780_12982# pulse_shaper_en_0.hv_nor$1_0.in2 VAPWR VAPWR sg13_hv_pmos ad=3.4p pd=20.68u as=1.9p ps=10.38u w=10u l=0.4u
X11 transmission_gate_1.vout transmission_gate_0.vctrl r2 VGND sg13_hv_nmos ad=0.38p pd=2.38u as=0.38p ps=2.38u w=2u l=0.45u
X12 transmission_gate_1.vout transmission_gate_1.vctrl r1 VGND sg13_hv_nmos ad=0.38p pd=2.38u as=0.38p ps=2.38u w=2u l=0.45u
X13 VAPWR pulse_shaper_en_0.hv_nand$1_0.in1 transmission_gate_0.nvctrl VAPWR sg13_hv_pmos ad=1.9p pd=10.38u as=1.9p ps=10.38u w=10u l=0.4u
X14 transmission_gate_1.vout transmission_gate_1.nvctrl r1 VAPWR sg13_hv_pmos ad=0.95p pd=5.38u as=0.95p ps=5.38u w=5u l=0.45u
X15 VGND lvl_shift_up_2.hv_inverter_6u5_0.in pulse_shaper_en_0.en VGND sg13_hv_nmos ad=0.68p pd=4.68u as=0.68p ps=4.68u w=2u l=0.45u
X16 transmission_gate_1.vout transmission_gate_1.vctrl r1 VGND sg13_hv_nmos ad=0.38p pd=2.38u as=0.38p ps=2.38u w=2u l=0.45u
X17 transmission_gate_0.vctrl transmission_gate_0.nvctrl VAPWR VAPWR sg13_hv_pmos ad=1.9p pd=10.38u as=1.9p ps=10.38u w=10u l=0.4u
X18 a_8856_6546# a_8856_6546# VGND VGND sg13_hv_nmos ad=0.408p pd=3.08u as=0.228p ps=1.58u w=1.2u l=1.5u
X19 transmission_gate_1.vctrl pulse_shaper_en_0.hv_nor$1_0.in1 VGND VGND sg13_hv_nmos ad=0.57p pd=3.38u as=1.02p ps=6.68u w=3u l=0.45u
X20 VGND clkin lvl_shift_up_0.hv_inverter_6u5_0.in VGND sg13_hv_nmos ad=3.4p pd=20.68u as=1.9p ps=10.38u w=10u l=0.45u
X21 transmission_gate_0.nvctrl pulse_shaper_en_0.hv_nand$1_0.in1 VAPWR VAPWR sg13_hv_pmos ad=1.9p pd=10.38u as=3.4p ps=20.68u w=10u l=0.4u
X22 vco_0.nout hv_mux4_0.in2 VAPWR VAPWR sg13_hv_pmos ad=1.9p pd=10.38u as=3.4p ps=20.68u w=10u l=0.4u
X23 a_2960_11830# hv_binary_decoder4_0.lsb VGND VGND sg13_hv_nmos ad=0.57p pd=3.38u as=0.57p ps=3.38u w=3u l=0.45u
X24 transmission_gate_2.vout hv_mux4_0.nsel3 ctrl VAPWR sg13_hv_pmos ad=0.95p pd=5.38u as=0.95p ps=5.38u w=5u l=0.45u
X25 VGND hv_binary_decoder4_0.lsb hv_binary_decoder4_0.hv_nand_0.in2 VGND sg13_hv_nmos ad=0.57p pd=3.38u as=0.57p ps=3.38u w=3u l=0.45u
X26 VGND a_8856_6546# a_8144_6546# VGND sg13_hv_nmos ad=0.228p pd=1.58u as=0.408p ps=3.08u w=1.2u l=1.5u
X27 VGND vco_0.comp_nmos$1_0.out vco_0.hv_rs-ff$1_0.nS VGND sg13_hv_nmos ad=0.68p pd=4.68u as=0.68p ps=4.68u w=2u l=0.45u
X28 a_1966_3910# a_2102_1840# VGND rsil l=10u w=0.5u
X29 vco_0.comp_nmos$1_0.Ibias vco_0.comp_nmos$1_0.Ibias VGND VGND sg13_hv_nmos ad=0.408p pd=3.08u as=0.408p ps=3.08u w=1.2u l=1.5u
X30 a_1694_3910# a_1830_1840# VGND rsil l=10u w=0.5u
X31 VGND selB lvl_shift_up_1.hv_inverter_6u5_0.in VGND sg13_hv_nmos ad=3.4p pd=20.68u as=1.9p ps=10.38u w=10u l=0.45u
X32 a_11780_8302# hv_mux4_0.hv_nor4_0.in2 a_12880_8302# VAPWR sg13_hv_pmos ad=1.9p pd=10.38u as=3.4p ps=20.68u w=10u l=0.4u
X33 VGND pulse_shaper_en_0.hv_nor$1_0.in1 transmission_gate_1.vctrl VGND sg13_hv_nmos ad=1.02p pd=6.68u as=0.57p ps=3.38u w=3u l=0.45u
X34 a_12880_8302# hv_mux4_0.hv_nor_2.out a_13980_8302# VAPWR sg13_hv_pmos ad=1.9p pd=10.38u as=3.4p ps=20.68u w=10u l=0.4u
X35 transmission_gate_1.vctrl pulse_shaper_en_0.hv_nor$1_0.in1 VGND VGND sg13_hv_nmos ad=0.57p pd=3.38u as=0.57p ps=3.38u w=3u l=0.45u
X36 VGND hv_mux4_0.nsel4 hv_mux4_0.hv_nor_1.out VGND sg13_hv_nmos ad=1.02p pd=6.68u as=0.57p ps=3.38u w=3u l=0.45u
X37 hv_mux4_0.hv_nor_2.out hv_mux4_0.nsel3 VGND VGND sg13_hv_nmos ad=0.57p pd=3.38u as=1.02p ps=6.68u w=3u l=0.45u
X38 VAPWR hv_binary_decoder4_0.hv_nand_0.in2 hv_mux4_0.nsel1 VAPWR sg13_hv_pmos ad=3.4p pd=20.68u as=1.9p ps=10.38u w=10u l=0.4u
X39 vco_0.vc hv_mux4_0.in2 vco_0.bias_current_generator$1_0.5uA- VGND sg13_hv_nmos ad=0.102p pd=1.28u as=0.102p ps=1.28u w=0.3u l=0.45u
X40 VAPWR hv_binary_decoder4_0.hv_nand_0.in1 hv_mux4_0.nsel2 VAPWR sg13_hv_pmos ad=1.9p pd=10.38u as=1.9p ps=10.38u w=10u l=0.4u
X41 VAPWR lvl_shift_up_1.hv_inverter_6u5_0.in hv_binary_decoder4_0.msb VAPWR sg13_hv_pmos ad=2.21p pd=13.68u as=2.21p ps=13.68u w=6.5u l=0.4u
X42 VGND transmission_gate_1.vctrl transmission_gate_1.nvctrl VGND sg13_hv_nmos ad=0.57p pd=3.38u as=0.57p ps=3.38u w=3u l=0.45u
X43 transmission_gate_2.vout hv_inverter_40u_1.out ctrl VGND sg13_hv_nmos ad=0.38p pd=2.38u as=0.68p ps=4.68u w=2u l=0.45u
X44 hv_mux4_0.nsel2 hv_binary_decoder4_0.hv_nand_0.in1 VAPWR VAPWR sg13_hv_pmos ad=1.9p pd=10.38u as=3.4p ps=20.68u w=10u l=0.4u
X45 hv_mux4_0.in2 vco_0.hv_rs-ff$1_0.nS VAPWR VAPWR sg13_hv_pmos ad=1.9p pd=10.38u as=1.9p ps=10.38u w=10u l=0.4u
X46 a_12906_5408# ctrl VGND rhigh l=6.78u w=0.5u
X47 vco_0.nout vco_0.hv_rs-ff$1_0.nR VAPWR VAPWR sg13_hv_pmos ad=1.9p pd=10.38u as=1.9p ps=10.38u w=10u l=0.4u
X48 r1 transmission_gate_1.nvctrl transmission_gate_1.vout VAPWR sg13_hv_pmos ad=1.7p pd=10.68u as=0.95p ps=5.38u w=5u l=0.45u
X49 a_3870_3910# a_4006_1840# VGND rsil l=10u w=0.5u
X50 a_12634_5408# a_12770_3966# VGND rhigh l=6.78u w=0.5u
X51 a_3598_3910# a_3734_1840# VGND rsil l=10u w=0.5u
X52 a_11300_1983# a_9954_282# VGND VGND sg13_hv_nmos ad=2.04p pd=12.68u as=1.14p ps=6.38u w=6u l=5u
X53 a_13960_11830# pulse_shaper_en_0.hv_nand$1_0.in1 transmission_gate_0.nvctrl VGND sg13_hv_nmos ad=0.57p pd=3.38u as=0.57p ps=3.38u w=3u l=0.45u
X54 VAPWR vco_0.hv_rs-ff$1_0.nS hv_mux4_0.in2 VAPWR sg13_hv_pmos ad=1.9p pd=10.38u as=1.9p ps=10.38u w=10u l=0.4u
X55 a_2190_4622# hv_mux4_0.in2 vco_0.nout VGND sg13_hv_nmos ad=1.02p pd=6.68u as=0.57p ps=3.38u w=3u l=0.45u
X56 VAPWR vco_0.hv_rs-ff$1_0.nR vco_0.nout VAPWR sg13_hv_pmos ad=1.9p pd=10.38u as=1.9p ps=10.38u w=10u l=0.4u
X57 hv_mux4_0.hv_nor_2.out hv_mux4_0.in3 VGND VGND sg13_hv_nmos ad=0.57p pd=3.38u as=0.57p ps=3.38u w=3u l=0.45u
X58 pulse_shaper_en_0.hv_nand$1_0.in1 pulse_shaper_en_0.low_th_inverter_0.vin VAPWR VAPWR sg13_hv_pmos ad=0.19p pd=1.38u as=0.34p ps=2.68u w=1u l=0.4u
X59 a_760_11830# hv_binary_decoder4_0.hv_nand_0.in1 hv_mux4_0.nsel1 VGND sg13_hv_nmos ad=1.02p pd=6.68u as=0.57p ps=3.38u w=3u l=0.45u
X60 a_7380_8302# hv_mux4_0.nsel3 hv_mux4_0.hv_nor_2.out VAPWR sg13_hv_pmos ad=3.4p pd=20.68u as=1.9p ps=10.38u w=10u l=0.4u
X61 lvl_shift_up_1.hv_inverter_6u5_0.in selB VGND VGND sg13_hv_nmos ad=1.9p pd=10.38u as=3.4p ps=20.68u w=10u l=0.45u
X62 hv_mux4_0.nsel1 hv_binary_decoder4_0.hv_nand_0.in1 a_760_11830# VGND sg13_hv_nmos ad=0.57p pd=3.38u as=0.57p ps=3.38u w=3u l=0.45u
X63 a_2980_8302# hv_mux4_0.in1 VAPWR VAPWR sg13_hv_pmos ad=3.4p pd=20.68u as=1.9p ps=10.38u w=10u l=0.4u
X64 VAPWR hv_binary_decoder4_0.msb hv_binary_decoder4_0.hv_nand_0.in1 VAPWR sg13_hv_pmos ad=3.4p pd=20.68u as=1.9p ps=10.38u w=10u l=0.4u
X65 a_11780_8302# hv_mux4_0.hv_nor4_0.in2 a_12880_8302# VAPWR sg13_hv_pmos ad=1.9p pd=10.38u as=1.9p ps=10.38u w=10u l=0.4u
X66 a_7380_8302# hv_mux4_0.in3 VAPWR VAPWR sg13_hv_pmos ad=3.4p pd=20.68u as=1.9p ps=10.38u w=10u l=0.4u
X67 VGND hv_mux4_0.nsel3 hv_inverter_40u_1.out VGND sg13_hv_nmos ad=0.57p pd=3.38u as=0.57p ps=3.38u w=3u l=0.45u
X68 r1 transmission_gate_1.vctrl transmission_gate_1.vout VGND sg13_hv_nmos ad=0.38p pd=2.38u as=0.38p ps=2.38u w=2u l=0.45u
X69 a_11780_12982# pulse_shaper_en_0.hv_nor$1_0.in1 transmission_gate_1.vctrl VAPWR sg13_hv_pmos ad=3.4p pd=20.68u as=1.9p ps=10.38u w=10u l=0.4u
X70 r2 transmission_gate_0.vctrl transmission_gate_1.vout VGND sg13_hv_nmos ad=0.38p pd=2.38u as=0.38p ps=2.38u w=2u l=0.45u
X71 a_11780_12982# pulse_shaper_en_0.hv_nor$1_0.in2 VAPWR VAPWR sg13_hv_pmos ad=1.9p pd=10.38u as=1.9p ps=10.38u w=10u l=0.4u
X72 a_12880_8302# hv_mux4_0.hv_nor4_0.in2 a_11780_8302# VAPWR sg13_hv_pmos ad=1.9p pd=10.38u as=1.9p ps=10.38u w=10u l=0.4u
X73 hv_mux4_0.in2 vco_0.hv_rs-ff$1_0.nS a_4390_4622# VGND sg13_hv_nmos ad=0.57p pd=3.38u as=1.02p ps=6.68u w=3u l=0.45u
X74 r1 transmission_gate_1.nvctrl transmission_gate_1.vout VAPWR sg13_hv_pmos ad=0.95p pd=5.38u as=0.95p ps=5.38u w=5u l=0.45u
X75 VGND vco_0.hv_rs-ff$1_0.nR a_2190_4622# VGND sg13_hv_nmos ad=0.57p pd=3.38u as=1.02p ps=6.68u w=3u l=0.45u
X76 pulse_shaper_en_0.hv_nor$1_0.in2 pulse_shaper_en_0.en VAPWR VAPWR sg13_hv_pmos ad=1.9p pd=10.38u as=1.9p ps=10.38u w=10u l=0.4u
X77 a_1422_3910# a_1558_1840# VGND rsil l=10u w=0.5u
X78 r2 transmission_gate_0.vctrl transmission_gate_1.vout VGND sg13_hv_nmos ad=0.38p pd=2.38u as=0.38p ps=2.38u w=2u l=0.45u
X79 transmission_gate_1.vout transmission_gate_1.nvctrl r1 VAPWR sg13_hv_pmos ad=0.95p pd=5.38u as=0.95p ps=5.38u w=5u l=0.45u
X80 a_2960_11830# hv_binary_decoder4_0.hv_nand_0.in1 hv_mux4_0.nsel2 VGND sg13_hv_nmos ad=0.57p pd=3.38u as=0.57p ps=3.38u w=3u l=0.45u
X81 hv_mux4_0.nsel4 hv_binary_decoder4_0.lsb VAPWR VAPWR sg13_hv_pmos ad=1.9p pd=10.38u as=1.9p ps=10.38u w=10u l=0.4u
X82 ctrl hv_mux4_0.nsel3 transmission_gate_2.vout VAPWR sg13_hv_pmos ad=0.95p pd=5.38u as=0.95p ps=5.38u w=5u l=0.45u
X83 r2 transmission_gate_0.vctrl transmission_gate_1.vout VGND sg13_hv_nmos ad=0.38p pd=2.38u as=0.38p ps=2.38u w=2u l=0.45u
X84 hv_mux4_0.nsel1 hv_binary_decoder4_0.hv_nand_0.in1 a_760_11830# VGND sg13_hv_nmos ad=0.57p pd=3.38u as=1.02p ps=6.68u w=3u l=0.45u
X85 transmission_gate_1.vout transmission_gate_0.nvctrl r2 VAPWR sg13_hv_pmos ad=0.95p pd=5.38u as=0.95p ps=5.38u w=5u l=0.45u
X86 a_1150_3910# a_1014_1840# VGND rsil l=10u w=0.5u
X87 a_12906_5408# a_12770_3966# VGND rhigh l=6.78u w=0.5u
X88 a_7398_318# vco_0.bias_current_generator$1_0.current_reference_40uA$1_0.iout VAPWR VAPWR sg13_hv_pmos ad=0.95p pd=5.38u as=0.95p ps=5.38u w=5u l=2u
X89 a_11300_1983# a_11300_1983# VAPWR VAPWR sg13_hv_pmos ad=0.95p pd=5.38u as=0.95p ps=5.38u w=5u l=2u
X90 vco_0.voltage_mirror_pmos$1_0.Ibias a_12498_3966# VGND rhigh l=6.78u w=0.5u
X91 VGND hv_binary_decoder4_0.lsb a_7360_11830# VGND sg13_hv_nmos ad=0.57p pd=3.38u as=1.02p ps=6.68u w=3u l=0.45u
X92 ctrl hv_mux4_0.nsel3 transmission_gate_2.vout VAPWR sg13_hv_pmos ad=0.95p pd=5.38u as=0.95p ps=5.38u w=5u l=0.45u
X93 ctrl hv_mux4_0.nsel3 transmission_gate_2.vout VAPWR sg13_hv_pmos ad=0.95p pd=5.38u as=0.95p ps=5.38u w=5u l=0.45u
X94 hv_mux4_0.hv_nor4_0.in2 hv_mux4_0.in2 VGND VGND sg13_hv_nmos ad=0.57p pd=3.38u as=1.02p ps=6.68u w=3u l=0.45u
X95 transmission_gate_2.vout hv_mux4_0.nsel3 ctrl VAPWR sg13_hv_pmos ad=0.95p pd=5.38u as=0.95p ps=5.38u w=5u l=0.45u
X96 VAPWR hv_binary_decoder4_0.hv_nand_0.in1 hv_mux4_0.nsel1 VAPWR sg13_hv_pmos ad=3.4p pd=20.68u as=1.9p ps=10.38u w=10u l=0.4u
X97 a_9142_3986# a_9142_3986# VAPWR VAPWR sg13_hv_pmos ad=0.68p pd=4.68u as=0.38p ps=2.38u w=2u l=0.4u
X98 VAPWR hv_binary_decoder4_0.hv_nand_0.in2 hv_mux4_0.nsel1 VAPWR sg13_hv_pmos ad=1.9p pd=10.38u as=1.9p ps=10.38u w=10u l=0.4u
X99 transmission_gate_1.vout transmission_gate_0.vctrl r2 VGND sg13_hv_nmos ad=0.38p pd=2.38u as=0.38p ps=2.38u w=2u l=0.45u
X100 transmission_gate_1.vout transmission_gate_1.vctrl r1 VGND sg13_hv_nmos ad=0.38p pd=2.38u as=0.38p ps=2.38u w=2u l=0.45u
X101 transmission_gate_1.vout transmission_gate_1.nvctrl r1 VAPWR sg13_hv_pmos ad=0.95p pd=5.38u as=0.95p ps=5.38u w=5u l=0.45u
X102 r1 transmission_gate_1.vctrl transmission_gate_1.vout VGND sg13_hv_nmos ad=0.38p pd=2.38u as=0.38p ps=2.38u w=2u l=0.45u
X103 a_14556_2070# a_14556_2070# VGND VGND sg13_hv_nmos ad=2.04p pd=12.68u as=2.04p ps=12.68u w=6u l=5u
X104 a_3054_3910# a_2918_1840# VGND rsil l=10u w=0.5u
X105 r1 transmission_gate_1.vctrl transmission_gate_1.vout VGND sg13_hv_nmos ad=0.38p pd=2.38u as=0.38p ps=2.38u w=2u l=0.45u
X106 a_2782_3910# a_2646_1840# VGND rsil l=10u w=0.5u
X107 vco_0.bias_current_generator$1_0.5uA+ a_11300_1983# VAPWR VAPWR sg13_hv_pmos ad=0.95p pd=5.38u as=0.95p ps=5.38u w=5u l=2u
X108 a_7360_11830# hv_binary_decoder4_0.lsb VGND VGND sg13_hv_nmos ad=1.02p pd=6.68u as=0.57p ps=3.38u w=3u l=0.45u
X109 VGND pulse_shaper_en_0.hv_nor$1_0.in2 transmission_gate_1.vctrl VGND sg13_hv_nmos ad=0.57p pd=3.38u as=0.57p ps=3.38u w=3u l=0.45u
X110 transmission_gate_2.vout hv_mux4_0.nsel3 ctrl VAPWR sg13_hv_pmos ad=0.95p pd=5.38u as=0.95p ps=5.38u w=5u l=0.45u
X111 r1 transmission_gate_1.vctrl transmission_gate_1.vout VGND sg13_hv_nmos ad=0.38p pd=2.38u as=0.38p ps=2.38u w=2u l=0.45u
X112 VGND hv_mux4_0.nsel3 hv_mux4_0.hv_nor_2.out VGND sg13_hv_nmos ad=1.02p pd=6.68u as=0.57p ps=3.38u w=3u l=0.45u
X113 a_10284_7890# vco_0.comp_nmos$1_0.- VGND rhigh l=11.3u w=0.5u
X114 r2 transmission_gate_0.nvctrl transmission_gate_1.vout VAPWR sg13_hv_pmos ad=0.95p pd=5.38u as=0.95p ps=5.38u w=5u l=0.45u
X115 VGND hv_mux4_0.hv_nor_0.out hv_inverter_40u_0.in VGND sg13_hv_nmos ad=0.57p pd=3.38u as=0.57p ps=3.38u w=3u l=0.45u
X116 VAPWR a_1268_318# a_1268_318# VAPWR sg13_hv_pmos ad=1.9p pd=10.38u as=3.4p ps=20.68u w=10u l=2u
X117 hv_mux4_0.hv_nor_2.out hv_mux4_0.nsel3 VGND VGND sg13_hv_nmos ad=0.57p pd=3.38u as=0.57p ps=3.38u w=3u l=0.45u
X118 ctrl hv_inverter_40u_1.out transmission_gate_2.vout VGND sg13_hv_nmos ad=0.38p pd=2.38u as=0.38p ps=2.38u w=2u l=0.45u
X119 vco_0.comp_pmos$1_0.Ibias vco_0.comp_pmos$1_0.Ibias VAPWR VAPWR sg13_hv_pmos ad=0.68p pd=4.68u as=0.68p ps=4.68u w=2u l=0.4u
X120 ctrl hv_inverter_40u_1.out transmission_gate_2.vout VGND sg13_hv_nmos ad=0.38p pd=2.38u as=0.38p ps=2.38u w=2u l=0.45u
X121 VAPWR hv_mux4_0.in2 vco_0.nout VAPWR sg13_hv_pmos ad=3.4p pd=20.68u as=1.9p ps=10.38u w=10u l=0.4u
X122 clkout hv_inverter_40u_0.in VGND VGND sg13_hv_nmos ad=0.57p pd=3.38u as=0.57p ps=3.38u w=3u l=0.45u
X123 VGND pulse_shaper_en_0.low_th_inverter_0.vin pulse_shaper_en_0.hv_nor$1_0.in1 VGND sg13_hv_nmos ad=0.34p pd=2.68u as=0.19p ps=1.38u w=1u l=0.45u
X124 a_2190_4622# hv_mux4_0.in2 vco_0.nout VGND sg13_hv_nmos ad=0.57p pd=3.38u as=0.57p ps=3.38u w=3u l=0.45u
X125 pulse_shaper_en_0.hv_nor$1_0.in1 pulse_shaper_en_0.low_th_inverter_0.vin VGND VGND sg13_hv_nmos ad=0.19p pd=1.38u as=0.34p ps=2.68u w=1u l=0.45u
X126 transmission_gate_1.vout transmission_gate_0.nvctrl r2 VAPWR sg13_hv_pmos ad=0.95p pd=5.38u as=1.7p ps=10.68u w=5u l=0.45u
X127 VAPWR pulse_shaper_en_0.low_th_inverter_0.vin pulse_shaper_en_0.hv_nor$1_0.in1 VAPWR sg13_hv_pmos ad=3.4p pd=20.68u as=1.9p ps=10.38u w=10u l=0.4u
X128 VGND hv_mux4_0.nsel4 hv_mux4_0.hv_nor_1.out VGND sg13_hv_nmos ad=0.57p pd=3.38u as=0.57p ps=3.38u w=3u l=0.45u
X129 a_11780_12982# pulse_shaper_en_0.hv_nor$1_0.in1 transmission_gate_1.vctrl VAPWR sg13_hv_pmos ad=1.9p pd=10.38u as=1.9p ps=10.38u w=10u l=0.4u
X130 a_10078_3986# a_10078_3986# VGND VGND sg13_hv_nmos ad=2.04p pd=12.68u as=1.14p ps=6.38u w=6u l=5u
X131 ctrl hv_inverter_40u_1.out transmission_gate_2.vout VGND sg13_hv_nmos ad=0.38p pd=2.38u as=0.38p ps=2.38u w=2u l=0.45u
X132 a_9954_282# a_9954_282# VGND VGND sg13_hv_nmos ad=1.14p pd=6.38u as=1.14p ps=6.38u w=6u l=5u
X133 hv_binary_decoder4_0.hv_nand_0.in2 hv_binary_decoder4_0.lsb VAPWR VAPWR sg13_hv_pmos ad=1.9p pd=10.38u as=3.4p ps=20.68u w=10u l=0.4u
X134 vco_0.vc hv_mux4_0.in2 vco_0.bias_current_generator$1_0.5uA+ VAPWR sg13_hv_pmos ad=0.102p pd=1.28u as=0.102p ps=1.28u w=0.3u l=0.4u
X135 hv_mux4_0.hv_nor_1.out hv_mux4_0.nsel4 a_9580_8302# VAPWR sg13_hv_pmos ad=1.9p pd=10.38u as=3.4p ps=20.68u w=10u l=0.4u
X136 transmission_gate_2.vout hv_inverter_40u_1.out ctrl VGND sg13_hv_nmos ad=0.38p pd=2.38u as=0.38p ps=2.38u w=2u l=0.45u
X137 VAPWR hv_mux4_0.in2 a_5180_8302# VAPWR sg13_hv_pmos ad=1.9p pd=10.38u as=3.4p ps=20.68u w=10u l=0.4u
X138 hv_mux4_0.hv_nor_0.out hv_mux4_0.nsel1 a_2980_8302# VAPWR sg13_hv_pmos ad=1.9p pd=10.38u as=3.4p ps=20.68u w=10u l=0.4u
X139 transmission_gate_1.nvctrl transmission_gate_1.vctrl VAPWR VAPWR sg13_hv_pmos ad=1.9p pd=10.38u as=1.9p ps=10.38u w=10u l=0.4u
X140 hv_mux4_0.in2 vco_0.hv_rs-ff$1_0.nS a_4390_4622# VGND sg13_hv_nmos ad=0.57p pd=3.38u as=0.57p ps=3.38u w=3u l=0.45u
X141 VAPWR pulse_shaper_en_0.hv_nor$1_0.in2 a_11780_12982# VAPWR sg13_hv_pmos ad=1.9p pd=10.38u as=3.4p ps=20.68u w=10u l=0.4u
X142 a_760_11830# hv_binary_decoder4_0.hv_nand_0.in2 VGND VGND sg13_hv_nmos ad=0.57p pd=3.38u as=0.57p ps=3.38u w=3u l=0.45u
X143 VGND vco_0.hv_rs-ff$1_0.nR a_2190_4622# VGND sg13_hv_nmos ad=0.57p pd=3.38u as=0.57p ps=3.38u w=3u l=0.45u
X144 a_4614_4120# a_4278_1840# VGND rppd l=10.95u w=2u
X145 a_13980_8302# hv_mux4_0.hv_nor_2.out a_12880_8302# VAPWR sg13_hv_pmos ad=3.4p pd=20.68u as=1.9p ps=10.38u w=10u l=0.4u
X146 VAPWR selA lvl_shift_up_3.hv_inverter_6u5_0.in VAPWR sg13_hv_pmos ad=0.34p pd=2.68u as=0.19p ps=1.38u w=1u l=0.45u
X147 a_9580_8302# ctrl VAPWR VAPWR sg13_hv_pmos ad=3.4p pd=20.68u as=1.9p ps=10.38u w=10u l=0.4u
X148 hv_mux4_0.nsel4 hv_binary_decoder4_0.msb VAPWR VAPWR sg13_hv_pmos ad=1.9p pd=10.38u as=1.9p ps=10.38u w=10u l=0.4u
X149 VAPWR transmission_gate_0.nvctrl transmission_gate_0.vctrl VAPWR sg13_hv_pmos ad=3.4p pd=20.68u as=1.9p ps=10.38u w=10u l=0.4u
X150 a_62_1840# a_268_282# a_1268_318# VGND sg13_hv_nmos ad=1.14p pd=6.38u as=1.14p ps=6.38u w=6u l=5u
X151 a_878_3910# a_742_1840# VGND rsil l=10u w=0.5u
X152 vco_0.bias_current_generator$1_0.current_reference_40uA$1_0.iout vco_0.bias_current_generator$1_0.current_reference_40uA$1_0.iout VAPWR VAPWR sg13_hv_pmos ad=0.95p pd=5.38u as=1.7p ps=10.68u w=5u l=2u
X153 lvl_shift_up_0.hv_inverter_6u5_0.in clkin VAPWR VAPWR sg13_hv_pmos ad=0.19p pd=1.38u as=0.34p ps=2.68u w=1u l=0.45u
X154 VGND a_9954_282# vco_0.voltage_mirror_pmos$1_0.Ibias VGND sg13_hv_nmos ad=1.14p pd=6.38u as=2.04p ps=12.68u w=6u l=5u
X155 r2 transmission_gate_0.vctrl transmission_gate_1.vout VGND sg13_hv_nmos ad=0.38p pd=2.38u as=0.38p ps=2.38u w=2u l=0.45u
X156 VAPWR hv_binary_decoder4_0.lsb hv_mux4_0.nsel4 VAPWR sg13_hv_pmos ad=3.4p pd=20.68u as=1.9p ps=10.38u w=10u l=0.4u
X157 a_2782_3910# a_2918_1840# VGND rsil l=10u w=0.5u
X158 VAPWR vco_0.voltage_mirror_pmos$1_0.Ibias vco_0.comp_pmos$1_0.+ VAPWR sg13_hv_pmos ad=1.9p pd=10.38u as=3.4p ps=20.68u w=10u l=2u
X159 lvl_shift_up_0.hv_inverter_6u5_0.in clkin VGND VGND sg13_hv_nmos ad=1.9p pd=10.38u as=3.4p ps=20.68u w=10u l=0.45u
X160 hv_mux4_0.nsel4 hv_binary_decoder4_0.msb a_7360_11830# VGND sg13_hv_nmos ad=0.57p pd=3.38u as=1.02p ps=6.68u w=3u l=0.45u
X161 a_334_3910# a_470_1840# VGND rsil l=10u w=0.5u
X162 a_2510_3910# a_2374_1840# VGND rsil l=10u w=0.5u
X163 hv_mux4_0.hv_nor4_0.in2 hv_mux4_0.nsel2 VGND VGND sg13_hv_nmos ad=0.57p pd=3.38u as=1.02p ps=6.68u w=3u l=0.45u
X164 VAPWR hv_binary_decoder4_0.hv_nand_0.in1 hv_mux4_0.nsel1 VAPWR sg13_hv_pmos ad=1.9p pd=10.38u as=1.9p ps=10.38u w=10u l=0.4u
X165 r2 transmission_gate_0.vctrl transmission_gate_1.vout VGND sg13_hv_nmos ad=0.38p pd=2.38u as=0.38p ps=2.38u w=2u l=0.45u
X166 transmission_gate_1.vout transmission_gate_1.vctrl r1 VGND sg13_hv_nmos ad=0.38p pd=2.38u as=0.38p ps=2.38u w=2u l=0.45u
X167 r1 transmission_gate_1.nvctrl transmission_gate_1.vout VAPWR sg13_hv_pmos ad=0.95p pd=5.38u as=0.95p ps=5.38u w=5u l=0.45u
X168 hv_inverter_40u_1.out hv_mux4_0.nsel3 VAPWR VAPWR sg13_hv_pmos ad=1.9p pd=10.38u as=1.9p ps=10.38u w=10u l=0.4u
X169 a_9876_7890# a_10012_5544# VGND rhigh l=11.3u w=0.5u
X170 VAPWR hv_mux4_0.in3 a_7380_8302# VAPWR sg13_hv_pmos ad=1.9p pd=10.38u as=1.9p ps=10.38u w=10u l=0.4u
X171 hv_mux4_0.hv_nor4_0.in2 hv_mux4_0.nsel2 a_5180_8302# VAPWR sg13_hv_pmos ad=1.9p pd=10.38u as=1.9p ps=10.38u w=10u l=0.4u
X172 hv_mux4_0.nsel1 hv_binary_decoder4_0.hv_nand_0.in2 VAPWR VAPWR sg13_hv_pmos ad=1.9p pd=10.38u as=3.4p ps=20.68u w=10u l=0.4u
X173 vco_0.comp_nmos$1_0.Ibias vco_0.bias_current_generator$1_0.current_reference_40uA$1_0.iout VAPWR VAPWR sg13_hv_pmos ad=0.95p pd=5.38u as=0.95p ps=5.38u w=5u l=2u
X174 a_11300_1983# a_11300_1983# VAPWR VAPWR sg13_hv_pmos ad=0.95p pd=5.38u as=0.95p ps=5.38u w=5u l=2u
X175 transmission_gate_1.vout transmission_gate_1.nvctrl r1 VAPWR sg13_hv_pmos ad=0.95p pd=5.38u as=0.95p ps=5.38u w=5u l=0.45u
X176 hv_binary_decoder4_0.hv_nand_0.in2 hv_binary_decoder4_0.lsb VAPWR VAPWR sg13_hv_pmos ad=1.9p pd=10.38u as=1.9p ps=10.38u w=10u l=0.4u
X177 hv_mux4_0.in1 lvl_shift_up_0.hv_inverter_6u5_0.in VAPWR VAPWR sg13_hv_pmos ad=2.21p pd=13.68u as=2.21p ps=13.68u w=6.5u l=0.4u
X178 lvl_shift_up_3.hv_inverter_6u5_0.in selA VAPWR VAPWR sg13_hv_pmos ad=0.19p pd=1.38u as=0.34p ps=2.68u w=1u l=0.45u
X179 a_7380_8302# hv_mux4_0.in3 VAPWR VAPWR sg13_hv_pmos ad=1.9p pd=10.38u as=1.9p ps=10.38u w=10u l=0.4u
X180 a_5180_8302# hv_mux4_0.nsel2 hv_mux4_0.hv_nor4_0.in2 VAPWR sg13_hv_pmos ad=1.9p pd=10.38u as=1.9p ps=10.38u w=10u l=0.4u
X181 transmission_gate_2.vout hv_mux4_0.nsel3 ctrl VAPWR sg13_hv_pmos ad=0.95p pd=5.38u as=0.95p ps=5.38u w=5u l=0.45u
X182 VAPWR hv_binary_decoder4_0.lsb hv_binary_decoder4_0.hv_nand_0.in2 VAPWR sg13_hv_pmos ad=1.9p pd=10.38u as=1.9p ps=10.38u w=10u l=0.4u
X183 VGND hv_binary_decoder4_0.lsb a_7360_11830# VGND sg13_hv_nmos ad=0.57p pd=3.38u as=0.57p ps=3.38u w=3u l=0.45u
X184 transmission_gate_1.vout transmission_gate_0.nvctrl r2 VAPWR sg13_hv_pmos ad=0.95p pd=5.38u as=0.95p ps=5.38u w=5u l=0.45u
X185 VGND hv_mux4_0.in2 hv_mux4_0.hv_nor4_0.in2 VGND sg13_hv_nmos ad=1.02p pd=6.68u as=0.57p ps=3.38u w=3u l=0.45u
X186 transmission_gate_1.vout transmission_gate_0.vctrl r2 VGND sg13_hv_nmos ad=0.38p pd=2.38u as=0.38p ps=2.38u w=2u l=0.45u
X187 r1 transmission_gate_1.vctrl transmission_gate_1.vout VGND sg13_hv_nmos ad=0.38p pd=2.38u as=0.38p ps=2.38u w=2u l=0.45u
X188 VGND ctrl hv_mux4_0.hv_nor_1.out VGND sg13_hv_nmos ad=0.57p pd=3.38u as=0.57p ps=3.38u w=3u l=0.45u
X189 hv_mux4_0.hv_nor4_0.in2 hv_mux4_0.in2 VGND VGND sg13_hv_nmos ad=0.57p pd=3.38u as=0.57p ps=3.38u w=3u l=0.45u
X190 r2 transmission_gate_0.nvctrl transmission_gate_1.vout VAPWR sg13_hv_pmos ad=0.95p pd=5.38u as=0.95p ps=5.38u w=5u l=0.45u
X191 VGND hv_binary_decoder4_0.msb hv_binary_decoder4_0.hv_nand_0.in1 VGND sg13_hv_nmos ad=0.57p pd=3.38u as=0.57p ps=3.38u w=3u l=0.45u
X192 a_14556_2070# a_11300_1983# VAPWR VAPWR sg13_hv_pmos ad=0.95p pd=5.38u as=0.95p ps=5.38u w=5u l=2u
X193 transmission_gate_1.vout transmission_gate_0.vctrl r2 VGND sg13_hv_nmos ad=0.38p pd=2.38u as=0.38p ps=2.38u w=2u l=0.45u
X194 VGND a_7398_318# a_7398_318# VGND sg13_hv_nmos ad=1.14p pd=6.38u as=2.04p ps=12.68u w=6u l=5u
X195 hv_inverter_40u_0.in hv_mux4_0.hv_nor_1.out VGND VGND sg13_hv_nmos ad=0.57p pd=3.38u as=1.02p ps=6.68u w=3u l=0.45u
X196 r2 transmission_gate_0.vctrl transmission_gate_1.vout VGND sg13_hv_nmos ad=0.38p pd=2.38u as=0.38p ps=2.38u w=2u l=0.45u
X197 transmission_gate_1.vout transmission_gate_1.nvctrl r1 VAPWR sg13_hv_pmos ad=0.95p pd=5.38u as=0.95p ps=5.38u w=5u l=0.45u
X198 r1 transmission_gate_1.vctrl transmission_gate_1.vout VGND sg13_hv_nmos ad=0.38p pd=2.38u as=0.38p ps=2.38u w=2u l=0.45u
X199 VGND hv_mux4_0.in3 hv_mux4_0.hv_nor_2.out VGND sg13_hv_nmos ad=0.57p pd=3.38u as=0.57p ps=3.38u w=3u l=0.45u
X200 r1 transmission_gate_1.nvctrl transmission_gate_1.vout VAPWR sg13_hv_pmos ad=0.95p pd=5.38u as=0.95p ps=5.38u w=5u l=0.45u
X201 a_606_3910# a_470_1840# VGND rsil l=10u w=0.5u
X202 hv_mux4_0.in2 vco_0.hv_rs-ff$1_0.nS VAPWR VAPWR sg13_hv_pmos ad=1.9p pd=10.38u as=3.4p ps=20.68u w=10u l=0.4u
X203 vco_0.nout vco_0.hv_rs-ff$1_0.nR VAPWR VAPWR sg13_hv_pmos ad=1.9p pd=10.38u as=3.4p ps=20.68u w=10u l=0.4u
X204 clkout hv_inverter_40u_0.in VGND VGND sg13_hv_nmos ad=0.57p pd=3.38u as=1.02p ps=6.68u w=3u l=0.45u
X205 transmission_gate_1.vctrl pulse_shaper_en_0.hv_nor$1_0.in1 a_11780_12982# VAPWR sg13_hv_pmos ad=1.9p pd=10.38u as=3.4p ps=20.68u w=10u l=0.4u
X206 a_62_3910# a_198_1840# VGND rsil l=10u w=0.5u
X207 hv_mux4_0.nsel3 hv_binary_decoder4_0.hv_nand_0.in2 VAPWR VAPWR sg13_hv_pmos ad=1.9p pd=10.38u as=1.9p ps=10.38u w=10u l=0.4u
X208 a_2238_3910# a_2102_1840# VGND rsil l=10u w=0.5u
X209 VAPWR pulse_shaper_en_0.en pulse_shaper_en_0.hv_nor$1_0.in2 VAPWR sg13_hv_pmos ad=3.4p pd=20.68u as=1.9p ps=10.38u w=10u l=0.4u
X210 VAPWR transmission_gate_0.nvctrl transmission_gate_0.vctrl VAPWR sg13_hv_pmos ad=1.9p pd=10.38u as=1.9p ps=10.38u w=10u l=0.4u
X211 a_1966_3910# a_1830_1840# VGND rsil l=10u w=0.5u
X212 transmission_gate_1.vout transmission_gate_1.vctrl r1 VGND sg13_hv_nmos ad=0.38p pd=2.38u as=0.38p ps=2.38u w=2u l=0.45u
X213 VAPWR en lvl_shift_up_2.hv_inverter_6u5_0.in VAPWR sg13_hv_pmos ad=0.34p pd=2.68u as=0.19p ps=1.38u w=1u l=0.45u
X214 transmission_gate_1.vout transmission_gate_0.nvctrl r2 VAPWR sg13_hv_pmos ad=0.95p pd=5.38u as=0.95p ps=5.38u w=5u l=0.45u
X215 transmission_gate_2.vout hv_inverter_40u_1.out ctrl VGND sg13_hv_nmos ad=0.38p pd=2.38u as=0.38p ps=2.38u w=2u l=0.45u
X216 transmission_gate_0.vctrl transmission_gate_0.nvctrl VAPWR VAPWR sg13_hv_pmos ad=1.9p pd=10.38u as=3.4p ps=20.68u w=10u l=0.4u
X217 hv_inverter_40u_0.in hv_mux4_0.hv_nor_0.out a_11780_8302# VAPWR sg13_hv_pmos ad=1.9p pd=10.38u as=3.4p ps=20.68u w=10u l=0.4u
X218 ctrl hv_inverter_40u_1.out transmission_gate_2.vout VGND sg13_hv_nmos ad=0.38p pd=2.38u as=0.38p ps=2.38u w=2u l=0.45u
X219 VGND hv_binary_decoder4_0.hv_nand_0.in2 a_5160_11830# VGND sg13_hv_nmos ad=0.57p pd=3.38u as=1.02p ps=6.68u w=3u l=0.45u
X220 a_9222_4974# vco_0.comp_nmos$1_0.Ibias VGND VGND sg13_hv_nmos ad=0.816p pd=5.48u as=0.456p ps=2.78u w=2.4u l=1.5u
X221 hv_mux4_0.hv_nor_0.out hv_mux4_0.in1 VGND VGND sg13_hv_nmos ad=0.57p pd=3.38u as=1.02p ps=6.68u w=3u l=0.45u
X222 r2 transmission_gate_0.nvctrl transmission_gate_1.vout VAPWR sg13_hv_pmos ad=1.7p pd=10.68u as=0.95p ps=5.38u w=5u l=0.45u
X223 VAPWR vco_0.comp_nmos$1_0.out vco_0.hv_rs-ff$1_0.nS VAPWR sg13_hv_pmos ad=2.21p pd=13.68u as=2.21p ps=13.68u w=6.5u l=0.4u
X224 VAPWR vco_0.bias_current_generator$1_0.current_reference_40uA$1_0.iout vco_0.bias_current_generator$1_0.current_reference_40uA$1_0.iout VAPWR sg13_hv_pmos ad=0.95p pd=5.38u as=0.95p ps=5.38u w=5u l=2u
X225 hv_mux4_0.in2 vco_0.nout VAPWR VAPWR sg13_hv_pmos ad=1.9p pd=10.38u as=1.9p ps=10.38u w=10u l=0.4u
X226 VAPWR vco_0.bias_current_generator$1_0.current_reference_40uA$1_0.iout a_9954_282# VAPWR sg13_hv_pmos ad=0.95p pd=5.38u as=0.95p ps=5.38u w=5u l=2u
X227 ctrl hv_inverter_40u_1.out transmission_gate_2.vout VGND sg13_hv_nmos ad=0.38p pd=2.38u as=0.38p ps=2.38u w=2u l=0.45u
X228 a_10078_3986# vco_0.voltage_mirror_pmos$1_0.Ibias VAPWR VAPWR sg13_hv_pmos ad=3.4p pd=20.68u as=1.9p ps=10.38u w=10u l=2u
X229 a_7360_11830# hv_binary_decoder4_0.msb hv_mux4_0.nsel4 VGND sg13_hv_nmos ad=1.02p pd=6.68u as=0.57p ps=3.38u w=3u l=0.45u
X230 VAPWR vco_0.nout hv_mux4_0.in2 VAPWR sg13_hv_pmos ad=1.9p pd=10.38u as=1.9p ps=10.38u w=10u l=0.4u
X231 transmission_gate_2.vout hv_mux4_0.nsel3 ctrl VAPWR sg13_hv_pmos ad=0.95p pd=5.38u as=1.7p ps=10.68u w=5u l=0.45u
X232 a_2190_4622# vco_0.hv_rs-ff$1_0.nR VGND VGND sg13_hv_nmos ad=1.02p pd=6.68u as=0.57p ps=3.38u w=3u l=0.45u
X233 VGND pulse_shaper_en_0.hv_nor$1_0.in1 transmission_gate_1.vctrl VGND sg13_hv_nmos ad=0.57p pd=3.38u as=0.57p ps=3.38u w=3u l=0.45u
X234 hv_mux4_0.nsel4 hv_binary_decoder4_0.msb a_7360_11830# VGND sg13_hv_nmos ad=0.57p pd=3.38u as=0.57p ps=3.38u w=3u l=0.45u
X235 a_3326_3910# a_3462_1840# VGND rsil l=10u w=0.5u
X236 VGND hv_mux4_0.nsel2 hv_mux4_0.hv_nor4_0.in2 VGND sg13_hv_nmos ad=1.02p pd=6.68u as=0.57p ps=3.38u w=3u l=0.45u
X237 lvl_shift_up_2.hv_inverter_6u5_0.in en VAPWR VAPWR sg13_hv_pmos ad=0.19p pd=1.38u as=0.34p ps=2.68u w=1u l=0.45u
X238 transmission_gate_0.vctrl transmission_gate_0.nvctrl VGND VGND sg13_hv_nmos ad=0.57p pd=3.38u as=1.02p ps=6.68u w=3u l=0.45u
X239 hv_mux4_0.hv_nor4_0.in2 hv_mux4_0.nsel2 VGND VGND sg13_hv_nmos ad=0.57p pd=3.38u as=0.57p ps=3.38u w=3u l=0.45u
X240 a_5180_8302# hv_mux4_0.in2 VAPWR VAPWR sg13_hv_pmos ad=3.4p pd=20.68u as=1.9p ps=10.38u w=10u l=0.4u
X241 a_2980_8302# hv_mux4_0.nsel1 hv_mux4_0.hv_nor_0.out VAPWR sg13_hv_pmos ad=3.4p pd=20.68u as=1.9p ps=10.38u w=10u l=0.4u
X242 a_13980_8302# hv_mux4_0.hv_nor_1.out VAPWR VAPWR sg13_hv_pmos ad=1.9p pd=10.38u as=1.9p ps=10.38u w=10u l=0.4u
X243 a_4614_4120# VGND VGND rppd l=10.95u w=2u
X244 hv_inverter_40u_0.in hv_mux4_0.hv_nor_0.out a_11780_8302# VAPWR sg13_hv_pmos ad=1.9p pd=10.38u as=1.9p ps=10.38u w=10u l=0.4u
X245 hv_mux4_0.in3 osc_0.c2 VGND VGND sg13_hv_nmos ad=1.02p pd=6.68u as=0.57p ps=3.38u w=3u l=0.45u
X246 VAPWR a_9142_3986# a_8510_3986# VAPWR sg13_hv_pmos ad=0.38p pd=2.38u as=0.68p ps=4.68u w=2u l=0.4u
X247 VAPWR a_11300_1983# a_11300_1983# VAPWR sg13_hv_pmos ad=0.95p pd=5.38u as=0.95p ps=5.38u w=5u l=2u
X248 clkout hv_inverter_40u_0.in VPWR VPWR sg13_hv_pmos ad=1.9p pd=10.38u as=3.4p ps=20.68u w=10u l=0.4u
X249 VAPWR transmission_gate_2.vout osc_0.c1 VAPWR sg13_hv_pmos ad=0.19p pd=1.38u as=0.34p ps=2.68u w=1u l=2u
X250 a_9580_8302# ctrl VAPWR VAPWR sg13_hv_pmos ad=1.9p pd=10.38u as=1.9p ps=10.38u w=10u l=0.4u
X251 VAPWR hv_mux4_0.hv_nor_1.out a_13980_8302# VAPWR sg13_hv_pmos ad=1.9p pd=10.38u as=1.9p ps=10.38u w=10u l=0.4u
X252 transmission_gate_1.vout transmission_gate_0.nvctrl r2 VAPWR sg13_hv_pmos ad=0.95p pd=5.38u as=0.95p ps=5.38u w=5u l=0.45u
X253 a_11780_8302# hv_mux4_0.hv_nor_0.out hv_inverter_40u_0.in VAPWR sg13_hv_pmos ad=1.9p pd=10.38u as=1.9p ps=10.38u w=10u l=0.4u
X254 VGND vco_0.nout a_4390_4622# VGND sg13_hv_nmos ad=0.57p pd=3.38u as=1.02p ps=6.68u w=3u l=0.45u
X255 transmission_gate_1.vout transmission_gate_0.vctrl r2 VGND sg13_hv_nmos ad=0.38p pd=2.38u as=0.38p ps=2.38u w=2u l=0.45u
X256 hv_inverter_40u_0.in hv_mux4_0.hv_nor_2.out VGND VGND sg13_hv_nmos ad=0.57p pd=3.38u as=1.02p ps=6.68u w=3u l=0.45u
X257 VGND hv_mux4_0.nsel3 hv_mux4_0.hv_nor_2.out VGND sg13_hv_nmos ad=0.57p pd=3.38u as=0.57p ps=3.38u w=3u l=0.45u
X258 transmission_gate_1.vout transmission_gate_1.nvctrl r1 VAPWR sg13_hv_pmos ad=0.95p pd=5.38u as=0.95p ps=5.38u w=5u l=0.45u
X259 hv_mux4_0.in1 lvl_shift_up_0.hv_inverter_6u5_0.in VGND VGND sg13_hv_nmos ad=0.68p pd=4.68u as=0.68p ps=4.68u w=2u l=0.45u
X260 vco_0.bias_current_generator$1_0.current_reference_40uA$1_0.iout a_268_282# VGND VGND sg13_hv_nmos ad=2.04p pd=12.68u as=1.14p ps=6.38u w=6u l=5u
X261 transmission_gate_2.vout hv_inverter_40u_1.out ctrl VGND sg13_hv_nmos ad=0.38p pd=2.38u as=0.38p ps=2.38u w=2u l=0.45u
X262 VAPWR vco_0.voltage_mirror_pmos$1_0.Ibias vco_0.voltage_mirror_pmos$1_0.Ibias VAPWR sg13_hv_pmos ad=3.23p pd=19.68u as=1.805p ps=9.88u w=9.5u l=2u
X263 VGND a_268_282# a_268_282# VGND sg13_hv_nmos ad=1.14p pd=6.38u as=2.04p ps=12.68u w=6u l=5u
X264 r1 transmission_gate_1.nvctrl transmission_gate_1.vout VAPWR sg13_hv_pmos ad=0.95p pd=5.38u as=0.95p ps=5.38u w=5u l=0.45u
X265 a_1150_3910# a_1286_1840# VGND rsil l=10u w=0.5u
X266 VAPWR transmission_gate_2.vout transmission_gate_2.vout VAPWR sg13_hv_pmos ad=1.9p pd=10.38u as=3.4p ps=20.68u w=10u l=2u
X267 hv_mux4_0.nsel3 hv_binary_decoder4_0.msb VAPWR VAPWR sg13_hv_pmos ad=1.9p pd=10.38u as=1.9p ps=10.38u w=10u l=0.4u
X268 VAPWR transmission_gate_1.vctrl transmission_gate_1.nvctrl VAPWR sg13_hv_pmos ad=3.4p pd=20.68u as=1.9p ps=10.38u w=10u l=0.4u
X269 transmission_gate_1.vout transmission_gate_0.vctrl r2 VGND sg13_hv_nmos ad=0.38p pd=2.38u as=0.38p ps=2.38u w=2u l=0.45u
X270 VAPWR pulse_shaper_en_0.en pulse_shaper_en_0.hv_nor$1_0.in2 VAPWR sg13_hv_pmos ad=1.9p pd=10.38u as=1.9p ps=10.38u w=10u l=0.4u
X271 r1 transmission_gate_1.nvctrl transmission_gate_1.vout VAPWR sg13_hv_pmos ad=0.95p pd=5.38u as=0.95p ps=5.38u w=5u l=0.45u
X272 r2 transmission_gate_0.nvctrl transmission_gate_1.vout VAPWR sg13_hv_pmos ad=0.95p pd=5.38u as=0.95p ps=5.38u w=5u l=0.45u
X273 hv_mux4_0.nsel1 hv_binary_decoder4_0.hv_nand_0.in1 VAPWR VAPWR sg13_hv_pmos ad=1.9p pd=10.38u as=3.4p ps=20.68u w=10u l=0.4u
X274 VGND hv_mux4_0.hv_nor_1.out hv_inverter_40u_0.in VGND sg13_hv_nmos ad=1.02p pd=6.68u as=0.57p ps=3.38u w=3u l=0.45u
X275 VAPWR hv_binary_decoder4_0.msb hv_mux4_0.nsel4 VAPWR sg13_hv_pmos ad=3.4p pd=20.68u as=1.9p ps=10.38u w=10u l=0.4u
X276 VAPWR hv_binary_decoder4_0.lsb hv_mux4_0.nsel4 VAPWR sg13_hv_pmos ad=1.9p pd=10.38u as=1.9p ps=10.38u w=10u l=0.4u
X277 hv_inverter_40u_0.in hv_mux4_0.hv_nor_1.out VGND VGND sg13_hv_nmos ad=0.57p pd=3.38u as=0.57p ps=3.38u w=3u l=0.45u
X278 pulse_shaper_en_0.hv_nor$1_0.in2 pulse_shaper_en_0.en VAPWR VAPWR sg13_hv_pmos ad=1.9p pd=10.38u as=3.4p ps=20.68u w=10u l=0.4u
X279 a_12634_5408# a_12498_3966# VGND rhigh l=6.78u w=0.5u
X280 hv_mux4_0.nsel3 hv_binary_decoder4_0.msb a_5160_11830# VGND sg13_hv_nmos ad=0.57p pd=3.38u as=1.02p ps=6.68u w=3u l=0.45u
X281 hv_mux4_0.nsel4 hv_binary_decoder4_0.lsb VAPWR VAPWR sg13_hv_pmos ad=1.9p pd=10.38u as=3.4p ps=20.68u w=10u l=0.4u
X282 hv_mux4_0.hv_nor_0.out hv_mux4_0.nsel1 VGND VGND sg13_hv_nmos ad=0.57p pd=3.38u as=1.02p ps=6.68u w=3u l=0.45u
X283 a_9142_3986# vco_0.comp_nmos$1_0.- a_9222_4974# VGND sg13_hv_nmos ad=0.408p pd=3.08u as=0.228p ps=1.58u w=1.2u l=1.5u
X284 a_1268_318# a_268_282# a_62_1840# VGND sg13_hv_nmos ad=1.14p pd=6.38u as=1.14p ps=6.38u w=6u l=5u
X285 r2 transmission_gate_0.vctrl transmission_gate_1.vout VGND sg13_hv_nmos ad=0.38p pd=2.38u as=0.38p ps=2.38u w=2u l=0.45u
X286 r1 transmission_gate_1.nvctrl transmission_gate_1.vout VAPWR sg13_hv_pmos ad=0.95p pd=5.38u as=0.95p ps=5.38u w=5u l=0.45u
X287 a_9222_4974# vco_0.vc a_8510_3986# VGND sg13_hv_nmos ad=0.228p pd=1.58u as=0.408p ps=3.08u w=1.2u l=1.5u
X288 VAPWR hv_mux4_0.nsel3 hv_inverter_40u_1.out VAPWR sg13_hv_pmos ad=3.4p pd=20.68u as=1.9p ps=10.38u w=10u l=0.4u
X289 a_9954_282# a_9954_282# VGND VGND sg13_hv_nmos ad=1.14p pd=6.38u as=1.14p ps=6.38u w=6u l=5u
X290 a_5160_11830# hv_binary_decoder4_0.hv_nand_0.in2 VGND VGND sg13_hv_nmos ad=1.02p pd=6.68u as=0.57p ps=3.38u w=3u l=0.45u
X291 a_10284_7890# a_10420_5544# VGND rhigh l=11.3u w=0.5u
X292 VGND a_9954_282# a_9954_282# VGND sg13_hv_nmos ad=1.14p pd=6.38u as=1.14p ps=6.38u w=6u l=5u
X293 VGND hv_inverter_40u_0.in clkout VGND sg13_hv_nmos ad=0.57p pd=3.38u as=0.57p ps=3.38u w=3u l=0.45u
X294 VGND selA lvl_shift_up_3.hv_inverter_6u5_0.in VGND sg13_hv_nmos ad=3.4p pd=20.68u as=1.9p ps=10.38u w=10u l=0.45u
X295 r2 transmission_gate_0.vctrl transmission_gate_1.vout VGND sg13_hv_nmos ad=0.38p pd=2.38u as=0.38p ps=2.38u w=2u l=0.45u
X296 VGND hv_binary_decoder4_0.hv_nand_0.in2 a_5160_11830# VGND sg13_hv_nmos ad=0.57p pd=3.38u as=0.57p ps=3.38u w=3u l=0.45u
X297 transmission_gate_1.vout transmission_gate_0.nvctrl r2 VAPWR sg13_hv_pmos ad=0.95p pd=5.38u as=0.95p ps=5.38u w=5u l=0.45u
X298 transmission_gate_1.vout transmission_gate_1.vctrl r1 VGND sg13_hv_nmos ad=0.38p pd=2.38u as=0.38p ps=2.38u w=2u l=0.45u
X299 VGND hv_mux4_0.in1 hv_mux4_0.hv_nor_0.out VGND sg13_hv_nmos ad=1.02p pd=6.68u as=0.57p ps=3.38u w=3u l=0.45u
X300 pulse_shaper_en_0.hv_nor$1_0.in2 pulse_shaper_en_0.en VGND VGND sg13_hv_nmos ad=0.57p pd=3.38u as=1.02p ps=6.68u w=3u l=0.45u
X301 transmission_gate_0.nvctrl pulse_shaper_en_0.en VAPWR VAPWR sg13_hv_pmos ad=1.9p pd=10.38u as=1.9p ps=10.38u w=10u l=0.4u
X302 vco_0.hv_inverter_6u5$3_0.in a_8144_6546# VGND VGND sg13_hv_nmos ad=0.408p pd=3.08u as=0.408p ps=3.08u w=1.2u l=1.5u
X303 VGND vco_0.hv_inverter_6u5$3_0.in vco_0.hv_rs-ff$1_0.nR VGND sg13_hv_nmos ad=0.68p pd=4.68u as=0.68p ps=4.68u w=2u l=0.45u
X304 hv_mux4_0.hv_nor_0.out hv_mux4_0.in1 VGND VGND sg13_hv_nmos ad=0.57p pd=3.38u as=0.57p ps=3.38u w=3u l=0.45u
X305 a_760_11830# hv_binary_decoder4_0.hv_nand_0.in1 hv_mux4_0.nsel1 VGND sg13_hv_nmos ad=0.57p pd=3.38u as=0.57p ps=3.38u w=3u l=0.45u
X306 a_62_1840# a_268_282# a_1268_318# VGND sg13_hv_nmos ad=2.04p pd=12.68u as=1.14p ps=6.38u w=6u l=5u
X307 VAPWR vco_0.hv_rs-ff$1_0.nR vco_0.nout VAPWR sg13_hv_pmos ad=3.4p pd=20.68u as=1.9p ps=10.38u w=10u l=0.4u
X308 VAPWR selB lvl_shift_up_1.hv_inverter_6u5_0.in VAPWR sg13_hv_pmos ad=0.34p pd=2.68u as=0.19p ps=1.38u w=1u l=0.45u
X309 VAPWR a_11300_1983# a_11300_1983# VAPWR sg13_hv_pmos ad=0.95p pd=5.38u as=0.95p ps=5.38u w=5u l=2u
X310 transmission_gate_2.vout hv_inverter_40u_1.out ctrl VGND sg13_hv_nmos ad=0.38p pd=2.38u as=0.38p ps=2.38u w=2u l=0.45u
X311 a_4390_4622# vco_0.hv_rs-ff$1_0.nS hv_mux4_0.in2 VGND sg13_hv_nmos ad=0.57p pd=3.38u as=0.57p ps=3.38u w=3u l=0.45u
X312 VAPWR vco_0.bias_current_generator$1_0.current_reference_40uA$1_0.iout a_7398_318# VAPWR sg13_hv_pmos ad=0.95p pd=5.38u as=0.95p ps=5.38u w=5u l=2u
X313 a_2190_4622# vco_0.hv_rs-ff$1_0.nR VGND VGND sg13_hv_nmos ad=0.57p pd=3.38u as=0.57p ps=3.38u w=3u l=0.45u
X314 ctrl hv_mux4_0.nsel3 transmission_gate_2.vout VAPWR sg13_hv_pmos ad=0.95p pd=5.38u as=0.95p ps=5.38u w=5u l=0.45u
X315 a_878_3910# a_1014_1840# VGND rsil l=10u w=0.5u
X316 VGND pulse_shaper_en_0.en a_13960_11830# VGND sg13_hv_nmos ad=0.57p pd=3.38u as=1.02p ps=6.68u w=3u l=0.45u
X317 ctrl hv_mux4_0.nsel3 transmission_gate_2.vout VAPWR sg13_hv_pmos ad=0.95p pd=5.38u as=0.95p ps=5.38u w=5u l=0.45u
X318 a_7360_11830# hv_binary_decoder4_0.lsb VGND VGND sg13_hv_nmos ad=0.57p pd=3.38u as=0.57p ps=3.38u w=3u l=0.45u
X319 VGND transmission_gate_0.nvctrl transmission_gate_0.vctrl VGND sg13_hv_nmos ad=1.02p pd=6.68u as=0.57p ps=3.38u w=3u l=0.45u
X320 VGND hv_mux4_0.in2 hv_mux4_0.hv_nor4_0.in2 VGND sg13_hv_nmos ad=0.57p pd=3.38u as=0.57p ps=3.38u w=3u l=0.45u
X321 VGND en lvl_shift_up_2.hv_inverter_6u5_0.in VGND sg13_hv_nmos ad=3.4p pd=20.68u as=1.9p ps=10.38u w=10u l=0.45u
X322 VAPWR hv_mux4_0.in3 a_7380_8302# VAPWR sg13_hv_pmos ad=1.9p pd=10.38u as=3.4p ps=20.68u w=10u l=0.4u
X323 hv_mux4_0.hv_nor4_0.in2 hv_mux4_0.nsel2 a_5180_8302# VAPWR sg13_hv_pmos ad=1.9p pd=10.38u as=3.4p ps=20.68u w=10u l=0.4u
X324 transmission_gate_0.vctrl transmission_gate_0.nvctrl VGND VGND sg13_hv_nmos ad=0.57p pd=3.38u as=0.57p ps=3.38u w=3u l=0.45u
X325 VGND vco_0.nout a_4390_4622# VGND sg13_hv_nmos ad=0.57p pd=3.38u as=0.57p ps=3.38u w=3u l=0.45u
X326 a_12880_8302# hv_mux4_0.hv_nor4_0.in2 a_11780_8302# VAPWR sg13_hv_pmos ad=3.4p pd=20.68u as=1.9p ps=10.38u w=10u l=0.4u
X327 a_9580_8302# hv_mux4_0.nsel4 hv_mux4_0.hv_nor_1.out VAPWR sg13_hv_pmos ad=3.4p pd=20.68u as=1.9p ps=10.38u w=10u l=0.4u
X328 ctrl hv_inverter_40u_1.out transmission_gate_2.vout VGND sg13_hv_nmos ad=0.68p pd=4.68u as=0.38p ps=2.38u w=2u l=0.45u
X329 lvl_shift_up_3.hv_inverter_6u5_0.in selA VGND VGND sg13_hv_nmos ad=1.9p pd=10.38u as=3.4p ps=20.68u w=10u l=0.45u
X330 ctrl hv_mux4_0.nsel3 transmission_gate_2.vout VAPWR sg13_hv_pmos ad=0.95p pd=5.38u as=0.95p ps=5.38u w=5u l=0.45u
X331 hv_mux4_0.nsel2 hv_binary_decoder4_0.lsb VAPWR VAPWR sg13_hv_pmos ad=1.9p pd=10.38u as=1.9p ps=10.38u w=10u l=0.4u
X332 r1 transmission_gate_1.vctrl transmission_gate_1.vout VGND sg13_hv_nmos ad=0.38p pd=2.38u as=0.38p ps=2.38u w=2u l=0.45u
X333 transmission_gate_2.vout hv_mux4_0.nsel3 ctrl VAPWR sg13_hv_pmos ad=0.95p pd=5.38u as=0.95p ps=5.38u w=5u l=0.45u
X334 VAPWR transmission_gate_1.vctrl transmission_gate_1.nvctrl VAPWR sg13_hv_pmos ad=1.9p pd=10.38u as=1.9p ps=10.38u w=10u l=0.4u
X335 vco_0.comp_pmos$1_0.Ibias a_7398_318# VGND VGND sg13_hv_nmos ad=2.04p pd=12.68u as=1.14p ps=6.38u w=6u l=5u
X336 r1 transmission_gate_1.nvctrl transmission_gate_1.vout VAPWR sg13_hv_pmos ad=0.95p pd=5.38u as=0.95p ps=5.38u w=5u l=0.45u
X337 VGND hv_mux4_0.hv_nor_2.out hv_inverter_40u_0.in VGND sg13_hv_nmos ad=1.02p pd=6.68u as=0.57p ps=3.38u w=3u l=0.45u
X338 VAPWR hv_binary_decoder4_0.hv_nand_0.in2 hv_mux4_0.nsel3 VAPWR sg13_hv_pmos ad=3.4p pd=20.68u as=1.9p ps=10.38u w=10u l=0.4u
X339 VAPWR hv_binary_decoder4_0.msb hv_mux4_0.nsel4 VAPWR sg13_hv_pmos ad=1.9p pd=10.38u as=1.9p ps=10.38u w=10u l=0.4u
X340 a_2510_3910# a_2646_1840# VGND rsil l=10u w=0.5u
X341 hv_inverter_40u_0.in hv_mux4_0.hv_nor_2.out VGND VGND sg13_hv_nmos ad=0.57p pd=3.38u as=0.57p ps=3.38u w=3u l=0.45u
X342 lvl_shift_up_1.hv_inverter_6u5_0.in selB VAPWR VAPWR sg13_hv_pmos ad=0.19p pd=1.38u as=0.34p ps=2.68u w=1u l=0.45u
X343 VGND osc_0.c1 osc_0.c1 VGND sg13_hv_nmos ad=0.19p pd=1.38u as=0.34p ps=2.68u w=1u l=2u
X344 ctrl hv_inverter_40u_1.out transmission_gate_2.vout VGND sg13_hv_nmos ad=0.38p pd=2.38u as=0.38p ps=2.38u w=2u l=0.45u
X345 pulse_shaper_en_0.low_th_inverter_0.vin hv_inverter_40u_0.in VAPWR VAPWR sg13_hv_pmos ad=0.102p pd=1.28u as=0.102p ps=1.28u w=0.3u l=0.4u
X346 VPWR hv_inverter_40u_0.in clkout VPWR sg13_hv_pmos ad=3.4p pd=20.68u as=1.9p ps=10.38u w=10u l=0.4u
X347 VGND hv_binary_decoder4_0.lsb a_2960_11830# VGND sg13_hv_nmos ad=0.57p pd=3.38u as=1.02p ps=6.68u w=3u l=0.45u
X348 hv_mux4_0.nsel4 hv_binary_decoder4_0.msb VAPWR VAPWR sg13_hv_pmos ad=1.9p pd=10.38u as=3.4p ps=20.68u w=10u l=0.4u
X349 vco_0.comp_pmos$1_0.+ a_10012_5544# VGND rhigh l=11.3u w=0.5u
X350 transmission_gate_1.vout transmission_gate_0.nvctrl r2 VAPWR sg13_hv_pmos ad=0.95p pd=5.38u as=0.95p ps=5.38u w=5u l=0.45u
X351 VGND hv_inverter_40u_0.in clkout VGND sg13_hv_nmos ad=1.02p pd=6.68u as=0.57p ps=3.38u w=3u l=0.45u
X352 hv_mux4_0.hv_nor_2.out hv_mux4_0.nsel3 a_7380_8302# VAPWR sg13_hv_pmos ad=1.9p pd=10.38u as=1.9p ps=10.38u w=10u l=0.4u
X353 lvl_shift_up_2.hv_inverter_6u5_0.in en VGND VGND sg13_hv_nmos ad=1.9p pd=10.38u as=3.4p ps=20.68u w=10u l=0.45u
X354 VAPWR hv_mux4_0.in1 a_2980_8302# VAPWR sg13_hv_pmos ad=1.9p pd=10.38u as=1.9p ps=10.38u w=10u l=0.4u
X355 hv_binary_decoder4_0.hv_nand_0.in1 hv_binary_decoder4_0.msb VAPWR VAPWR sg13_hv_pmos ad=1.9p pd=10.38u as=1.9p ps=10.38u w=10u l=0.4u
X356 a_7380_8302# hv_mux4_0.nsel3 hv_mux4_0.hv_nor_2.out VAPWR sg13_hv_pmos ad=1.9p pd=10.38u as=1.9p ps=10.38u w=10u l=0.4u
X357 transmission_gate_2.vout hv_inverter_40u_1.out ctrl VGND sg13_hv_nmos ad=0.38p pd=2.38u as=0.38p ps=2.38u w=2u l=0.45u
X358 a_2980_8302# hv_mux4_0.in1 VAPWR VAPWR sg13_hv_pmos ad=1.9p pd=10.38u as=1.9p ps=10.38u w=10u l=0.4u
X359 VAPWR hv_binary_decoder4_0.msb hv_binary_decoder4_0.hv_nand_0.in1 VAPWR sg13_hv_pmos ad=1.9p pd=10.38u as=1.9p ps=10.38u w=10u l=0.4u
X360 a_5160_11830# hv_binary_decoder4_0.msb hv_mux4_0.nsel3 VGND sg13_hv_nmos ad=1.02p pd=6.68u as=0.57p ps=3.38u w=3u l=0.45u
X361 VAPWR hv_mux4_0.nsel3 hv_inverter_40u_1.out VAPWR sg13_hv_pmos ad=1.9p pd=10.38u as=1.9p ps=10.38u w=10u l=0.4u
X362 transmission_gate_1.vout transmission_gate_0.vctrl r2 VGND sg13_hv_nmos ad=0.38p pd=2.38u as=0.38p ps=2.38u w=2u l=0.45u
X363 hv_mux4_0.nsel3 hv_binary_decoder4_0.msb a_5160_11830# VGND sg13_hv_nmos ad=0.57p pd=3.38u as=0.57p ps=3.38u w=3u l=0.45u
X364 r2 transmission_gate_0.nvctrl transmission_gate_1.vout VAPWR sg13_hv_pmos ad=0.95p pd=5.38u as=0.95p ps=5.38u w=5u l=0.45u
X365 VGND hv_mux4_0.nsel1 hv_mux4_0.hv_nor_0.out VGND sg13_hv_nmos ad=1.02p pd=6.68u as=0.57p ps=3.38u w=3u l=0.45u
X366 transmission_gate_0.nvctrl pulse_shaper_en_0.hv_nand$1_0.in1 VAPWR VAPWR sg13_hv_pmos ad=1.9p pd=10.38u as=1.9p ps=10.38u w=10u l=0.4u
X367 transmission_gate_1.vout transmission_gate_1.nvctrl r1 VAPWR sg13_hv_pmos ad=0.95p pd=5.38u as=0.95p ps=5.38u w=5u l=0.45u
X368 hv_mux4_0.hv_nor_0.out hv_mux4_0.nsel1 VGND VGND sg13_hv_nmos ad=0.57p pd=3.38u as=0.57p ps=3.38u w=3u l=0.45u
X369 a_4142_3910# a_4006_1840# VGND rsil l=10u w=0.5u
X370 a_1268_318# a_268_282# a_62_1840# VGND sg13_hv_nmos ad=1.14p pd=6.38u as=2.04p ps=12.68u w=6u l=5u
X371 a_3870_3910# a_3734_1840# VGND rsil l=10u w=0.5u
X372 transmission_gate_2.vout hv_inverter_40u_1.out ctrl VGND sg13_hv_nmos ad=0.38p pd=2.38u as=0.38p ps=2.38u w=2u l=0.45u
X373 a_8674_7374# vco_0.comp_pmos$1_0.Ibias VAPWR VAPWR sg13_hv_pmos ad=0.68p pd=4.68u as=0.38p ps=2.38u w=2u l=0.4u
X374 osc_0.c2 transmission_gate_2.vout VAPWR VAPWR sg13_hv_pmos ad=0.34p pd=2.68u as=0.19p ps=1.38u w=1u l=2u
X375 transmission_gate_0.nvctrl pulse_shaper_en_0.hv_nand$1_0.in1 a_13960_11830# VGND sg13_hv_nmos ad=0.57p pd=3.38u as=1.02p ps=6.68u w=3u l=0.45u
X376 a_7360_11830# hv_binary_decoder4_0.msb hv_mux4_0.nsel4 VGND sg13_hv_nmos ad=0.57p pd=3.38u as=0.57p ps=3.38u w=3u l=0.45u
X377 VAPWR vco_0.comp_pmos$1_0.Ibias vco_0.hv_inverter_6u5$3_0.in VAPWR sg13_hv_pmos ad=0.38p pd=2.38u as=0.68p ps=4.68u w=2u l=0.4u
X378 hv_inverter_40u_0.in hv_mux4_0.hv_nor4_0.in2 VGND VGND sg13_hv_nmos ad=0.57p pd=3.38u as=1.02p ps=6.68u w=3u l=0.45u
X379 VGND pulse_shaper_en_0.en pulse_shaper_en_0.hv_nor$1_0.in2 VGND sg13_hv_nmos ad=1.02p pd=6.68u as=0.57p ps=3.38u w=3u l=0.45u
X380 hv_mux4_0.in2 vco_0.nout VAPWR VAPWR sg13_hv_pmos ad=1.9p pd=10.38u as=3.4p ps=20.68u w=10u l=0.4u
X381 VGND hv_mux4_0.nsel2 hv_mux4_0.hv_nor4_0.in2 VGND sg13_hv_nmos ad=0.57p pd=3.38u as=0.57p ps=3.38u w=3u l=0.45u
X382 pulse_shaper_en_0.hv_nor$1_0.in2 pulse_shaper_en_0.en VGND VGND sg13_hv_nmos ad=0.57p pd=3.38u as=0.57p ps=3.38u w=3u l=0.45u
X383 a_334_3910# a_198_1840# VGND rsil l=10u w=0.5u
X384 transmission_gate_1.vout transmission_gate_1.vctrl r1 VGND sg13_hv_nmos ad=0.38p pd=2.38u as=0.68p ps=4.68u w=2u l=0.45u
X385 VGND osc_0.c1 osc_0.out2 VGND sg13_hv_nmos ad=0.57p pd=3.38u as=1.02p ps=6.68u w=3u l=0.45u
X386 a_62_3910# a_62_1840# VGND rsil l=10u w=0.5u
X387 VAPWR vco_0.bias_current_generator$1_0.current_reference_40uA$1_0.iout vco_0.comp_nmos$1_0.Ibias VAPWR sg13_hv_pmos ad=0.95p pd=5.38u as=0.95p ps=5.38u w=5u l=2u
X388 hv_mux4_0.nsel2 hv_binary_decoder4_0.hv_nand_0.in1 VAPWR VAPWR sg13_hv_pmos ad=1.9p pd=10.38u as=1.9p ps=10.38u w=10u l=0.4u
X389 transmission_gate_1.vout transmission_gate_1.vctrl r1 VGND sg13_hv_nmos ad=0.38p pd=2.38u as=0.38p ps=2.38u w=2u l=0.45u
X390 transmission_gate_1.vout transmission_gate_0.nvctrl r2 VAPWR sg13_hv_pmos ad=0.95p pd=5.38u as=0.95p ps=5.38u w=5u l=0.45u
X391 a_13960_11830# pulse_shaper_en_0.en VGND VGND sg13_hv_nmos ad=1.02p pd=6.68u as=0.57p ps=3.38u w=3u l=0.45u
X392 VAPWR vco_0.hv_inverter_6u5$3_0.in vco_0.hv_rs-ff$1_0.nR VAPWR sg13_hv_pmos ad=2.21p pd=13.68u as=2.21p ps=13.68u w=6.5u l=0.4u
X393 r2 transmission_gate_0.nvctrl transmission_gate_1.vout VAPWR sg13_hv_pmos ad=0.95p pd=5.38u as=0.95p ps=5.38u w=5u l=0.45u
X394 a_1694_3910# a_1558_1840# VGND rsil l=10u w=0.5u
X395 VGND pulse_shaper_en_0.en a_13960_11830# VGND sg13_hv_nmos ad=0.57p pd=3.38u as=0.57p ps=3.38u w=3u l=0.45u
X396 VGND hv_mux4_0.hv_nor4_0.in2 hv_inverter_40u_0.in VGND sg13_hv_nmos ad=1.02p pd=6.68u as=0.57p ps=3.38u w=3u l=0.45u
X397 VAPWR hv_binary_decoder4_0.msb hv_mux4_0.nsel3 VAPWR sg13_hv_pmos ad=3.4p pd=20.68u as=1.9p ps=10.38u w=10u l=0.4u
X398 VAPWR hv_binary_decoder4_0.hv_nand_0.in2 hv_mux4_0.nsel3 VAPWR sg13_hv_pmos ad=1.9p pd=10.38u as=1.9p ps=10.38u w=10u l=0.4u
X399 VAPWR ctrl a_9580_8302# VAPWR sg13_hv_pmos ad=1.9p pd=10.38u as=3.4p ps=20.68u w=10u l=0.4u
X400 a_13980_8302# hv_mux4_0.hv_nor_1.out VAPWR VAPWR sg13_hv_pmos ad=1.9p pd=10.38u as=3.4p ps=20.68u w=10u l=0.4u
X401 transmission_gate_1.nvctrl transmission_gate_1.vctrl VAPWR VAPWR sg13_hv_pmos ad=1.9p pd=10.38u as=3.4p ps=20.68u w=10u l=0.4u
X402 hv_inverter_40u_0.in hv_mux4_0.hv_nor4_0.in2 VGND VGND sg13_hv_nmos ad=0.57p pd=3.38u as=0.57p ps=3.38u w=3u l=0.45u
X403 vco_0.voltage_mirror_pmos$1_0.Ibias vco_0.voltage_mirror_pmos$1_0.Ibias VAPWR VAPWR sg13_hv_pmos ad=1.805p pd=9.88u as=3.23p ps=19.68u w=9.5u l=2u
X404 VAPWR transmission_gate_2.vout hv_mux4_0.in3 VAPWR sg13_hv_pmos ad=3.4p pd=20.68u as=3.4p ps=20.68u w=10u l=2u
X405 hv_mux4_0.nsel2 hv_binary_decoder4_0.hv_nand_0.in1 a_2960_11830# VGND sg13_hv_nmos ad=0.57p pd=3.38u as=1.02p ps=6.68u w=3u l=0.45u
X406 hv_mux4_0.nsel3 hv_binary_decoder4_0.hv_nand_0.in2 VAPWR VAPWR sg13_hv_pmos ad=1.9p pd=10.38u as=3.4p ps=20.68u w=10u l=0.4u
X407 VGND pulse_shaper_en_0.low_th_inverter_0.vin pulse_shaper_en_0.hv_nand$1_0.in1 VGND sg13_hv_nmos ad=0.34p pd=2.68u as=0.19p ps=1.38u w=1u l=0.45u
X408 transmission_gate_2.vout hv_mux4_0.nsel3 ctrl VAPWR sg13_hv_pmos ad=0.95p pd=5.38u as=0.95p ps=5.38u w=5u l=0.45u
X409 r2 transmission_gate_0.vctrl transmission_gate_1.vout VGND sg13_hv_nmos ad=0.68p pd=4.68u as=0.38p ps=2.38u w=2u l=0.45u
X410 hv_binary_decoder4_0.hv_nand_0.in2 hv_binary_decoder4_0.lsb VGND VGND sg13_hv_nmos ad=0.57p pd=3.38u as=1.02p ps=6.68u w=3u l=0.45u
X411 ctrl hv_mux4_0.nsel3 transmission_gate_2.vout VAPWR sg13_hv_pmos ad=0.95p pd=5.38u as=0.95p ps=5.38u w=5u l=0.45u
X412 vco_0.nout hv_mux4_0.in2 VAPWR VAPWR sg13_hv_pmos ad=1.9p pd=10.38u as=1.9p ps=10.38u w=10u l=0.4u
X413 VAPWR a_11300_1983# a_14556_2070# VAPWR sg13_hv_pmos ad=1.7p pd=10.68u as=0.95p ps=5.38u w=5u l=2u
X414 VGND vco_0.comp_nmos$1_0.Ibias vco_0.comp_nmos$1_0.out VGND sg13_hv_nmos ad=0.456p pd=2.78u as=0.816p ps=5.48u w=2.4u l=1.5u
X415 VAPWR pulse_shaper_en_0.low_th_inverter_0.vin pulse_shaper_en_0.hv_nand$1_0.in1 VAPWR sg13_hv_pmos ad=0.34p pd=2.68u as=0.19p ps=1.38u w=1u l=0.4u
X416 vco_0.bias_current_generator$1_0.5uA- a_14556_2070# VGND VGND sg13_hv_nmos ad=2.04p pd=12.68u as=2.04p ps=12.68u w=6u l=5u
X417 VGND lvl_shift_up_1.hv_inverter_6u5_0.in hv_binary_decoder4_0.msb VGND sg13_hv_nmos ad=0.68p pd=4.68u as=0.68p ps=4.68u w=2u l=0.45u
X418 a_3598_3910# a_3462_1840# VGND rsil l=10u w=0.5u
X419 VGND hv_mux4_0.hv_nor_1.out hv_inverter_40u_0.in VGND sg13_hv_nmos ad=0.57p pd=3.38u as=0.57p ps=3.38u w=3u l=0.45u
X420 a_4390_4622# vco_0.nout VGND VGND sg13_hv_nmos ad=1.02p pd=6.68u as=0.57p ps=3.38u w=3u l=0.45u
X421 VAPWR hv_mux4_0.in2 vco_0.nout VAPWR sg13_hv_pmos ad=1.9p pd=10.38u as=1.9p ps=10.38u w=10u l=0.4u
X422 a_4390_4622# vco_0.hv_rs-ff$1_0.nS hv_mux4_0.in2 VGND sg13_hv_nmos ad=1.02p pd=6.68u as=0.57p ps=3.38u w=3u l=0.45u
X423 a_2960_11830# hv_binary_decoder4_0.lsb VGND VGND sg13_hv_nmos ad=1.02p pd=6.68u as=0.57p ps=3.38u w=3u l=0.45u
X424 VGND hv_binary_decoder4_0.lsb a_2960_11830# VGND sg13_hv_nmos ad=0.57p pd=3.38u as=0.57p ps=3.38u w=3u l=0.45u
X425 ctrl hv_mux4_0.nsel3 transmission_gate_2.vout VAPWR sg13_hv_pmos ad=0.95p pd=5.38u as=0.95p ps=5.38u w=5u l=0.45u
X426 VGND hv_binary_decoder4_0.lsb hv_binary_decoder4_0.hv_nand_0.in2 VGND sg13_hv_nmos ad=1.02p pd=6.68u as=0.57p ps=3.38u w=3u l=0.45u
X427 transmission_gate_1.nvctrl transmission_gate_1.vctrl VGND VGND sg13_hv_nmos ad=0.57p pd=3.38u as=1.02p ps=6.68u w=3u l=0.45u
X428 VAPWR pulse_shaper_en_0.hv_nor$1_0.in2 a_11780_12982# VAPWR sg13_hv_pmos ad=1.9p pd=10.38u as=1.9p ps=10.38u w=10u l=0.4u
X429 a_3054_3910# a_3190_1840# VGND rsil l=10u w=0.5u
X430 a_5180_8302# hv_mux4_0.nsel2 hv_mux4_0.hv_nor4_0.in2 VAPWR sg13_hv_pmos ad=3.4p pd=20.68u as=1.9p ps=10.38u w=10u l=0.4u
X431 hv_inverter_40u_1.out hv_mux4_0.nsel3 VAPWR VAPWR sg13_hv_pmos ad=1.9p pd=10.38u as=3.4p ps=20.68u w=10u l=0.4u
X432 VAPWR hv_binary_decoder4_0.lsb hv_binary_decoder4_0.hv_nand_0.in2 VAPWR sg13_hv_pmos ad=3.4p pd=20.68u as=1.9p ps=10.38u w=10u l=0.4u
X433 hv_binary_decoder4_0.hv_nand_0.in2 hv_binary_decoder4_0.lsb VGND VGND sg13_hv_nmos ad=0.57p pd=3.38u as=0.57p ps=3.38u w=3u l=0.45u
X434 a_12880_8302# hv_mux4_0.hv_nor_2.out a_13980_8302# VAPWR sg13_hv_pmos ad=1.9p pd=10.38u as=1.9p ps=10.38u w=10u l=0.4u
X435 VAPWR ctrl a_9580_8302# VAPWR sg13_hv_pmos ad=1.9p pd=10.38u as=1.9p ps=10.38u w=10u l=0.4u
X436 VAPWR pulse_shaper_en_0.en transmission_gate_0.nvctrl VAPWR sg13_hv_pmos ad=3.4p pd=20.68u as=1.9p ps=10.38u w=10u l=0.4u
X437 r1 transmission_gate_1.vctrl transmission_gate_1.vout VGND sg13_hv_nmos ad=0.38p pd=2.38u as=0.38p ps=2.38u w=2u l=0.45u
X438 ctrl hv_inverter_40u_1.out transmission_gate_2.vout VGND sg13_hv_nmos ad=0.38p pd=2.38u as=0.38p ps=2.38u w=2u l=0.45u
X439 a_13980_8302# hv_mux4_0.hv_nor_2.out a_12880_8302# VAPWR sg13_hv_pmos ad=1.9p pd=10.38u as=1.9p ps=10.38u w=10u l=0.4u
X440 transmission_gate_1.vout transmission_gate_0.vctrl r2 VGND sg13_hv_nmos ad=0.38p pd=2.38u as=0.38p ps=2.38u w=2u l=0.45u
X441 vco_0.nout hv_mux4_0.in2 a_2190_4622# VGND sg13_hv_nmos ad=0.57p pd=3.38u as=1.02p ps=6.68u w=3u l=0.45u
X442 r1 transmission_gate_1.vctrl transmission_gate_1.vout VGND sg13_hv_nmos ad=0.68p pd=4.68u as=0.38p ps=2.38u w=2u l=0.45u
X443 r2 transmission_gate_0.nvctrl transmission_gate_1.vout VAPWR sg13_hv_pmos ad=0.95p pd=5.38u as=0.95p ps=5.38u w=5u l=0.45u
X444 a_5160_11830# hv_binary_decoder4_0.hv_nand_0.in2 VGND VGND sg13_hv_nmos ad=0.57p pd=3.38u as=0.57p ps=3.38u w=3u l=0.45u
X445 hv_inverter_40u_0.in hv_mux4_0.hv_nor_0.out VGND VGND sg13_hv_nmos ad=0.57p pd=3.38u as=1.02p ps=6.68u w=3u l=0.45u
X446 VGND transmission_gate_1.vctrl transmission_gate_1.nvctrl VGND sg13_hv_nmos ad=1.02p pd=6.68u as=0.57p ps=3.38u w=3u l=0.45u
X447 VGND hv_mux4_0.in1 hv_mux4_0.hv_nor_0.out VGND sg13_hv_nmos ad=0.57p pd=3.38u as=0.57p ps=3.38u w=3u l=0.45u
X448 transmission_gate_1.nvctrl transmission_gate_1.vctrl VGND VGND sg13_hv_nmos ad=0.57p pd=3.38u as=0.57p ps=3.38u w=3u l=0.45u
X449 a_1422_3910# a_1286_1840# VGND rsil l=10u w=0.5u
X450 r2 transmission_gate_0.nvctrl transmission_gate_1.vout VAPWR sg13_hv_pmos ad=0.95p pd=5.38u as=0.95p ps=5.38u w=5u l=0.45u
X451 a_9876_7890# VGND VGND rhigh l=11.3u w=0.5u
X452 ctrl hv_inverter_40u_1.out transmission_gate_2.vout VGND sg13_hv_nmos ad=0.38p pd=2.38u as=0.38p ps=2.38u w=2u l=0.45u
X453 ctrl hv_inverter_40u_1.out transmission_gate_2.vout VGND sg13_hv_nmos ad=0.38p pd=2.38u as=0.38p ps=2.38u w=2u l=0.45u
X454 transmission_gate_2.vout hv_inverter_40u_1.out ctrl VGND sg13_hv_nmos ad=0.38p pd=2.38u as=0.38p ps=2.38u w=2u l=0.45u
X455 hv_inverter_40u_1.out hv_mux4_0.nsel3 VGND VGND sg13_hv_nmos ad=0.57p pd=3.38u as=1.02p ps=6.68u w=3u l=0.45u
X456 hv_mux4_0.nsel1 hv_binary_decoder4_0.hv_nand_0.in2 VAPWR VAPWR sg13_hv_pmos ad=1.9p pd=10.38u as=1.9p ps=10.38u w=10u l=0.4u
X457 transmission_gate_1.vout transmission_gate_1.nvctrl r1 VAPWR sg13_hv_pmos ad=0.95p pd=5.38u as=0.95p ps=5.38u w=5u l=0.45u
X458 a_13960_11830# pulse_shaper_en_0.hv_nand$1_0.in1 transmission_gate_0.nvctrl VGND sg13_hv_nmos ad=1.02p pd=6.68u as=0.57p ps=3.38u w=3u l=0.45u
X459 transmission_gate_2.vout hv_mux4_0.nsel3 ctrl VAPWR sg13_hv_pmos ad=0.95p pd=5.38u as=0.95p ps=5.38u w=5u l=0.45u
X460 transmission_gate_1.vout transmission_gate_0.nvctrl r2 VAPWR sg13_hv_pmos ad=0.95p pd=5.38u as=0.95p ps=5.38u w=5u l=0.45u
X461 VGND a_9954_282# a_9954_282# VGND sg13_hv_nmos ad=1.14p pd=6.38u as=1.14p ps=6.38u w=6u l=5u
X462 transmission_gate_0.nvctrl pulse_shaper_en_0.hv_nand$1_0.in1 a_13960_11830# VGND sg13_hv_nmos ad=0.57p pd=3.38u as=0.57p ps=3.38u w=3u l=0.45u
X463 VGND hv_mux4_0.hv_nor_0.out hv_inverter_40u_0.in VGND sg13_hv_nmos ad=1.02p pd=6.68u as=0.57p ps=3.38u w=3u l=0.45u
X464 hv_mux4_0.hv_nor_1.out hv_mux4_0.nsel4 VGND VGND sg13_hv_nmos ad=0.57p pd=3.38u as=1.02p ps=6.68u w=3u l=0.45u
X465 VAPWR hv_binary_decoder4_0.lsb hv_mux4_0.nsel2 VAPWR sg13_hv_pmos ad=3.4p pd=20.68u as=1.9p ps=10.38u w=10u l=0.4u
X466 VAPWR hv_binary_decoder4_0.msb hv_mux4_0.nsel3 VAPWR sg13_hv_pmos ad=1.9p pd=10.38u as=1.9p ps=10.38u w=10u l=0.4u
X467 VGND transmission_gate_0.nvctrl transmission_gate_0.vctrl VGND sg13_hv_nmos ad=0.57p pd=3.38u as=0.57p ps=3.38u w=3u l=0.45u
X468 hv_inverter_40u_0.in hv_mux4_0.hv_nor_0.out VGND VGND sg13_hv_nmos ad=0.57p pd=3.38u as=0.57p ps=3.38u w=3u l=0.45u
X469 osc_0.c2 osc_0.c2 VGND VGND sg13_hv_nmos ad=0.34p pd=2.68u as=0.19p ps=1.38u w=1u l=2u
X470 transmission_gate_1.vout transmission_gate_1.vctrl r1 VGND sg13_hv_nmos ad=0.38p pd=2.38u as=0.38p ps=2.38u w=2u l=0.45u
X471 transmission_gate_2.vout hv_inverter_40u_1.out ctrl VGND sg13_hv_nmos ad=0.38p pd=2.38u as=0.38p ps=2.38u w=2u l=0.45u
X472 a_3326_3910# a_3190_1840# VGND rsil l=10u w=0.5u
X473 osc_0.out2 transmission_gate_2.vout VAPWR VAPWR sg13_hv_pmos ad=3.4p pd=20.68u as=1.9p ps=10.38u w=10u l=2u
X474 hv_mux4_0.nsel3 hv_binary_decoder4_0.msb VAPWR VAPWR sg13_hv_pmos ad=1.9p pd=10.38u as=3.4p ps=20.68u w=10u l=0.4u
X475 transmission_gate_1.vout transmission_gate_1.vctrl r1 VGND sg13_hv_nmos ad=0.38p pd=2.38u as=0.38p ps=2.38u w=2u l=0.45u
X476 VGND hv_mux4_0.nsel3 hv_inverter_40u_1.out VGND sg13_hv_nmos ad=1.02p pd=6.68u as=0.57p ps=3.38u w=3u l=0.45u
X477 VAPWR a_11300_1983# vco_0.bias_current_generator$1_0.5uA+ VAPWR sg13_hv_pmos ad=0.95p pd=5.38u as=0.95p ps=5.38u w=5u l=2u
X478 hv_inverter_40u_1.out hv_mux4_0.nsel3 VGND VGND sg13_hv_nmos ad=0.57p pd=3.38u as=0.57p ps=3.38u w=3u l=0.45u
X479 VAPWR a_10420_5544# VGND rhigh l=11.3u w=0.5u
X480 VGND hv_mux4_0.hv_nor_2.out hv_inverter_40u_0.in VGND sg13_hv_nmos ad=0.57p pd=3.38u as=0.57p ps=3.38u w=3u l=0.45u
X481 transmission_gate_1.vout transmission_gate_0.vctrl r2 VGND sg13_hv_nmos ad=0.38p pd=2.38u as=0.68p ps=4.68u w=2u l=0.45u
X482 VAPWR lvl_shift_up_3.hv_inverter_6u5_0.in hv_binary_decoder4_0.lsb VAPWR sg13_hv_pmos ad=2.21p pd=13.68u as=2.21p ps=13.68u w=6.5u l=0.4u
X483 transmission_gate_1.vout transmission_gate_1.nvctrl r1 VAPWR sg13_hv_pmos ad=0.95p pd=5.38u as=1.7p ps=10.68u w=5u l=0.45u
X484 a_2960_11830# hv_binary_decoder4_0.hv_nand_0.in1 hv_mux4_0.nsel2 VGND sg13_hv_nmos ad=1.02p pd=6.68u as=0.57p ps=3.38u w=3u l=0.45u
X485 a_8856_6546# vco_0.vc a_8674_7374# VAPWR sg13_hv_pmos ad=0.68p pd=4.68u as=0.38p ps=2.38u w=2u l=0.4u
X486 r1 transmission_gate_1.nvctrl transmission_gate_1.vout VAPWR sg13_hv_pmos ad=0.95p pd=5.38u as=0.95p ps=5.38u w=5u l=0.45u
X487 hv_mux4_0.nsel2 hv_binary_decoder4_0.hv_nand_0.in1 a_2960_11830# VGND sg13_hv_nmos ad=0.57p pd=3.38u as=0.57p ps=3.38u w=3u l=0.45u
X488 r2 transmission_gate_0.nvctrl transmission_gate_1.vout VAPWR sg13_hv_pmos ad=0.95p pd=5.38u as=0.95p ps=5.38u w=5u l=0.45u
X489 VGND hv_binary_decoder4_0.msb hv_binary_decoder4_0.hv_nand_0.in1 VGND sg13_hv_nmos ad=1.02p pd=6.68u as=0.57p ps=3.38u w=3u l=0.45u
X490 transmission_gate_1.vctrl pulse_shaper_en_0.hv_nor$1_0.in1 a_11780_12982# VAPWR sg13_hv_pmos ad=1.9p pd=10.38u as=1.9p ps=10.38u w=10u l=0.4u
X491 VAPWR vco_0.nout hv_mux4_0.in2 VAPWR sg13_hv_pmos ad=3.4p pd=20.68u as=1.9p ps=10.38u w=10u l=0.4u
X492 VAPWR vco_0.hv_rs-ff$1_0.nS hv_mux4_0.in2 VAPWR sg13_hv_pmos ad=3.4p pd=20.68u as=1.9p ps=10.38u w=10u l=0.4u
X493 hv_binary_decoder4_0.hv_nand_0.in1 hv_binary_decoder4_0.msb VGND VGND sg13_hv_nmos ad=0.57p pd=3.38u as=0.57p ps=3.38u w=3u l=0.45u
X494 VGND lvl_shift_up_3.hv_inverter_6u5_0.in hv_binary_decoder4_0.lsb VGND sg13_hv_nmos ad=0.68p pd=4.68u as=0.68p ps=4.68u w=2u l=0.45u
X495 a_8674_7374# vco_0.comp_pmos$1_0.+ a_8144_6546# VAPWR sg13_hv_pmos ad=0.38p pd=2.38u as=0.68p ps=4.68u w=2u l=0.4u
X496 a_4390_4622# vco_0.nout VGND VGND sg13_hv_nmos ad=0.57p pd=3.38u as=0.57p ps=3.38u w=3u l=0.45u
X497 VAPWR pulse_shaper_en_0.hv_nand$1_0.in1 transmission_gate_0.nvctrl VAPWR sg13_hv_pmos ad=3.4p pd=20.68u as=1.9p ps=10.38u w=10u l=0.4u
X498 VAPWR pulse_shaper_en_0.en transmission_gate_0.nvctrl VAPWR sg13_hv_pmos ad=1.9p pd=10.38u as=1.9p ps=10.38u w=10u l=0.4u
X499 pulse_shaper_en_0.low_th_inverter_0.vin hv_inverter_40u_0.in VGND VGND sg13_hv_nmos ad=0.102p pd=1.28u as=0.102p ps=1.28u w=0.3u l=0.45u
X500 transmission_gate_1.vctrl pulse_shaper_en_0.hv_nor$1_0.in2 VGND VGND sg13_hv_nmos ad=0.57p pd=3.38u as=1.02p ps=6.68u w=3u l=0.45u
X501 transmission_gate_0.nvctrl pulse_shaper_en_0.en VAPWR VAPWR sg13_hv_pmos ad=1.9p pd=10.38u as=3.4p ps=20.68u w=10u l=0.4u
X502 clkout hv_inverter_40u_0.in VPWR VPWR sg13_hv_pmos ad=1.9p pd=10.38u as=1.9p ps=10.38u w=10u l=0.4u
X503 a_5160_11830# hv_binary_decoder4_0.msb hv_mux4_0.nsel3 VGND sg13_hv_nmos ad=0.57p pd=3.38u as=0.57p ps=3.38u w=3u l=0.45u
X504 hv_mux4_0.hv_nor_2.out hv_mux4_0.nsel3 a_7380_8302# VAPWR sg13_hv_pmos ad=1.9p pd=10.38u as=3.4p ps=20.68u w=10u l=0.4u
X505 transmission_gate_2.vout hv_mux4_0.nsel3 ctrl VAPWR sg13_hv_pmos ad=0.95p pd=5.38u as=0.95p ps=5.38u w=5u l=0.45u
X506 VAPWR hv_mux4_0.in1 a_2980_8302# VAPWR sg13_hv_pmos ad=1.9p pd=10.38u as=3.4p ps=20.68u w=10u l=0.4u
X507 hv_mux4_0.hv_nor_1.out ctrl VGND VGND sg13_hv_nmos ad=0.57p pd=3.38u as=1.02p ps=6.68u w=3u l=0.45u
X508 vco_0.nout hv_mux4_0.in2 a_2190_4622# VGND sg13_hv_nmos ad=0.57p pd=3.38u as=0.57p ps=3.38u w=3u l=0.45u
X509 VAPWR hv_mux4_0.hv_nor_1.out a_13980_8302# VAPWR sg13_hv_pmos ad=3.4p pd=20.68u as=1.9p ps=10.38u w=10u l=0.4u
X510 VGND hv_mux4_0.nsel1 hv_mux4_0.hv_nor_0.out VGND sg13_hv_nmos ad=0.57p pd=3.38u as=0.57p ps=3.38u w=3u l=0.45u
X511 a_11780_8302# hv_mux4_0.hv_nor_0.out hv_inverter_40u_0.in VAPWR sg13_hv_pmos ad=3.4p pd=20.68u as=1.9p ps=10.38u w=10u l=0.4u
X512 VPWR hv_inverter_40u_0.in clkout VPWR sg13_hv_pmos ad=1.9p pd=10.38u as=1.9p ps=10.38u w=10u l=0.4u
X513 r2 transmission_gate_0.nvctrl transmission_gate_1.vout VAPWR sg13_hv_pmos ad=0.95p pd=5.38u as=0.95p ps=5.38u w=5u l=0.45u
X514 hv_binary_decoder4_0.hv_nand_0.in1 hv_binary_decoder4_0.msb VGND VGND sg13_hv_nmos ad=0.57p pd=3.38u as=1.02p ps=6.68u w=3u l=0.45u
X515 hv_mux4_0.nsel1 hv_binary_decoder4_0.hv_nand_0.in1 VAPWR VAPWR sg13_hv_pmos ad=1.9p pd=10.38u as=1.9p ps=10.38u w=10u l=0.4u
X516 a_606_3910# a_742_1840# VGND rsil l=10u w=0.5u
X517 VGND pulse_shaper_en_0.hv_nor$1_0.in2 transmission_gate_1.vctrl VGND sg13_hv_nmos ad=1.02p pd=6.68u as=0.57p ps=3.38u w=3u l=0.45u
X518 hv_binary_decoder4_0.hv_nand_0.in1 hv_binary_decoder4_0.msb VAPWR VAPWR sg13_hv_pmos ad=1.9p pd=10.38u as=3.4p ps=20.68u w=10u l=0.4u
X519 ctrl hv_mux4_0.nsel3 transmission_gate_2.vout VAPWR sg13_hv_pmos ad=1.7p pd=10.68u as=0.95p ps=5.38u w=5u l=0.45u
X520 transmission_gate_1.vctrl pulse_shaper_en_0.hv_nor$1_0.in2 VGND VGND sg13_hv_nmos ad=0.57p pd=3.38u as=0.57p ps=3.38u w=3u l=0.45u
X521 VGND ctrl hv_mux4_0.hv_nor_1.out VGND sg13_hv_nmos ad=1.02p pd=6.68u as=0.57p ps=3.38u w=3u l=0.45u
X522 hv_mux4_0.hv_nor_2.out hv_mux4_0.in3 VGND VGND sg13_hv_nmos ad=0.57p pd=3.38u as=1.02p ps=6.68u w=3u l=0.45u
X523 VAPWR hv_binary_decoder4_0.hv_nand_0.in1 hv_mux4_0.nsel2 VAPWR sg13_hv_pmos ad=3.4p pd=20.68u as=1.9p ps=10.38u w=10u l=0.4u
X524 VAPWR hv_binary_decoder4_0.lsb hv_mux4_0.nsel2 VAPWR sg13_hv_pmos ad=1.9p pd=10.38u as=1.9p ps=10.38u w=10u l=0.4u
X525 VGND pulse_shaper_en_0.en pulse_shaper_en_0.hv_nor$1_0.in2 VGND sg13_hv_nmos ad=0.57p pd=3.38u as=0.57p ps=3.38u w=3u l=0.45u
X526 a_268_282# a_1268_318# VAPWR VAPWR sg13_hv_pmos ad=3.4p pd=20.68u as=1.9p ps=10.38u w=10u l=2u
X527 VGND a_10078_3986# vco_0.comp_nmos$1_0.- VGND sg13_hv_nmos ad=1.14p pd=6.38u as=2.04p ps=12.68u w=6u l=5u
X528 hv_mux4_0.hv_nor_1.out ctrl VGND VGND sg13_hv_nmos ad=0.57p pd=3.38u as=0.57p ps=3.38u w=3u l=0.45u
X529 a_2238_3910# a_2374_1840# VGND rsil l=10u w=0.5u
X530 r2 transmission_gate_0.vctrl transmission_gate_1.vout VGND sg13_hv_nmos ad=0.38p pd=2.38u as=0.38p ps=2.38u w=2u l=0.45u
X531 r1 transmission_gate_1.vctrl transmission_gate_1.vout VGND sg13_hv_nmos ad=0.38p pd=2.38u as=0.38p ps=2.38u w=2u l=0.45u
X532 transmission_gate_2.vout hv_inverter_40u_1.out ctrl VGND sg13_hv_nmos ad=0.38p pd=2.38u as=0.38p ps=2.38u w=2u l=0.45u
X533 VGND hv_binary_decoder4_0.hv_nand_0.in2 a_760_11830# VGND sg13_hv_nmos ad=0.57p pd=3.38u as=1.02p ps=6.68u w=3u l=0.45u
X534 r1 transmission_gate_1.nvctrl transmission_gate_1.vout VAPWR sg13_hv_pmos ad=0.95p pd=5.38u as=0.95p ps=5.38u w=5u l=0.45u
X535 hv_mux4_0.nsel2 hv_binary_decoder4_0.lsb VAPWR VAPWR sg13_hv_pmos ad=1.9p pd=10.38u as=3.4p ps=20.68u w=10u l=0.4u
X536 transmission_gate_1.vout transmission_gate_0.vctrl r2 VGND sg13_hv_nmos ad=0.38p pd=2.38u as=0.38p ps=2.38u w=2u l=0.45u
X537 hv_mux4_0.hv_nor_1.out hv_mux4_0.nsel4 a_9580_8302# VAPWR sg13_hv_pmos ad=1.9p pd=10.38u as=1.9p ps=10.38u w=10u l=0.4u
X538 VAPWR hv_mux4_0.in2 a_5180_8302# VAPWR sg13_hv_pmos ad=1.9p pd=10.38u as=1.9p ps=10.38u w=10u l=0.4u
X539 hv_mux4_0.hv_nor_0.out hv_mux4_0.nsel1 a_2980_8302# VAPWR sg13_hv_pmos ad=1.9p pd=10.38u as=1.9p ps=10.38u w=10u l=0.4u
X540 ctrl hv_mux4_0.nsel3 transmission_gate_2.vout VAPWR sg13_hv_pmos ad=0.95p pd=5.38u as=0.95p ps=5.38u w=5u l=0.45u
X541 a_13960_11830# pulse_shaper_en_0.en VGND VGND sg13_hv_nmos ad=0.57p pd=3.38u as=0.57p ps=3.38u w=3u l=0.45u
X542 vco_0.comp_nmos$1_0.out a_8510_3986# VAPWR VAPWR sg13_hv_pmos ad=0.68p pd=4.68u as=0.68p ps=4.68u w=2u l=0.4u
X543 a_9580_8302# hv_mux4_0.nsel4 hv_mux4_0.hv_nor_1.out VAPWR sg13_hv_pmos ad=1.9p pd=10.38u as=1.9p ps=10.38u w=10u l=0.4u
X544 VGND hv_mux4_0.in3 hv_mux4_0.hv_nor_2.out VGND sg13_hv_nmos ad=1.02p pd=6.68u as=0.57p ps=3.38u w=3u l=0.45u
X545 a_5180_8302# hv_mux4_0.in2 VAPWR VAPWR sg13_hv_pmos ad=1.9p pd=10.38u as=1.9p ps=10.38u w=10u l=0.4u
X546 a_2980_8302# hv_mux4_0.nsel1 hv_mux4_0.hv_nor_0.out VAPWR sg13_hv_pmos ad=1.9p pd=10.38u as=1.9p ps=10.38u w=10u l=0.4u
X547 VGND hv_mux4_0.hv_nor4_0.in2 hv_inverter_40u_0.in VGND sg13_hv_nmos ad=0.57p pd=3.38u as=0.57p ps=3.38u w=3u l=0.45u
X548 hv_mux4_0.hv_nor_1.out hv_mux4_0.nsel4 VGND VGND sg13_hv_nmos ad=0.57p pd=3.38u as=0.57p ps=3.38u w=3u l=0.45u
X549 transmission_gate_1.vout transmission_gate_0.nvctrl r2 VAPWR sg13_hv_pmos ad=0.95p pd=5.38u as=0.95p ps=5.38u w=5u l=0.45u
C0 clkout VGND 27.16975f
C1 r2 VGND 31.31447f
C2 r1 VGND 38.10471f
C3 VPWR VGND 7.86242f
C4 VAPWR VGND 0.53162p
C5 vco_0.bias_current_generator$1_0.5uA- VGND 1.48947f
C6 vco_0.bias_current_generator$1_0.5uA+ VGND 2.76812f
C7 a_12906_5408# VGND 1.18f
C8 a_12770_3966# VGND 1.18f
C9 a_12634_5408# VGND 1.18f
C10 a_12498_3966# VGND 1.18f
C11 a_9142_3986# VGND 1.753f
C12 a_268_282# VGND 6.8719f
C13 a_4278_1840# VGND 2.72973f
C14 a_4142_3910# VGND 1.58633f
C15 a_4006_1840# VGND 1.58633f
C16 a_3870_3910# VGND 1.58633f
C17 a_3734_1840# VGND 1.58633f
C18 a_3598_3910# VGND 1.58633f
C19 a_3462_1840# VGND 1.58633f
C20 a_3326_3910# VGND 1.58633f
C21 a_3190_1840# VGND 1.58633f
C22 a_3054_3910# VGND 1.58633f
C23 a_2918_1840# VGND 1.58633f
C24 a_2782_3910# VGND 1.58633f
C25 a_2646_1840# VGND 1.58633f
C26 a_2510_3910# VGND 1.58633f
C27 a_2374_1840# VGND 1.58633f
C28 a_2238_3910# VGND 1.58633f
C29 a_2102_1840# VGND 1.58633f
C30 a_1966_3910# VGND 1.58633f
C31 a_1830_1840# VGND 1.58633f
C32 a_1694_3910# VGND 1.58633f
C33 a_1558_1840# VGND 1.58633f
C34 a_1422_3910# VGND 1.58633f
C35 a_1286_1840# VGND 1.58633f
C36 a_1150_3910# VGND 1.58633f
C37 a_1014_1840# VGND 1.58633f
C38 a_878_3910# VGND 1.58633f
C39 a_742_1840# VGND 1.58633f
C40 a_606_3910# VGND 1.58633f
C41 a_470_1840# VGND 1.58633f
C42 a_334_3910# VGND 1.58633f
C43 a_198_1840# VGND 1.58633f
C44 a_62_1840# VGND 19.25562f
C45 a_62_3910# VGND 1.58633f
C46 a_4614_4120# VGND 3.68942f
C47 a_10420_5544# VGND 1.78021f
C48 a_10284_7890# VGND 1.78021f
C49 a_10012_5544# VGND 1.78021f
C50 a_4390_4622# VGND 4.45078f
C51 a_2190_4622# VGND 6.1243f
C52 a_9222_4974# VGND 0.16632p
C53 vco_0.comp_nmos$1_0.out VGND 82.387f
C54 a_9876_7890# VGND 1.78021f
C55 a_8144_6546# VGND 6.06294f
C56 a_8674_7374# VGND 7.16015f
C57 transmission_gate_1.vout VGND 0.97487p
C58 a_13980_8302# VGND 22.6602f
C59 a_12880_8302# VGND 36.31834f
C60 a_11780_8302# VGND 27.88145f
C61 a_9580_8302# VGND 34.77385f
C62 a_7380_8302# VGND 14.83523f
C63 a_5180_8302# VGND 18.80065f
C64 a_2980_8302# VGND 22.2999f
C65 a_13960_11830# VGND 3.47632f
C66 a_7360_11830# VGND 3.47632f
C67 a_5160_11830# VGND 3.47632f
C68 a_2960_11830# VGND 19.17078f
C69 a_760_11830# VGND 12.31007f
C70 a_11780_12982# VGND 16.12815f
C71 hv_mux4_0.nsel2 VGND 1.08072f
C72 osc_0.out2 VGND 18.7051f
C73 lvl_shift_up_2.hv_inverter_6u5_0.in VGND 1.01118f
.ends
