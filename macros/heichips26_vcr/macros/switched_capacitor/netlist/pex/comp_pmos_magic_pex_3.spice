* PEX produced on Do 10. Sep 21:39:52 CEST 2026 using scripts/sak-pex.sh with m=3 and s=1 (extresist threshold=10000 mOhm, minres=1000 mOhm, mindelay=1 ps)
* NGSPICE file created from comp_pmos_pex.ext - technology: ihp-sg13cmos5l

.subckt comp_pmos_pex out - + VDD Ibias VSS
X0 a_n38_854# - a_n292_316# VDD sg13_hv_pmos ad=0.38p pd=2.38u as=0.68p ps=4.68u w=2u l=0.4u
X1 VSS.t4 a_118_854# out VSS.t3 sg13_hv_nmos ad=0.408p pd=3.08u as=0.408p ps=3.08u w=1.2u l=1.5u
X2 a_118_854# + a_n38_854# VDD sg13_hv_pmos ad=0.68p pd=4.68u as=0.38p ps=2.38u w=2u l=0.4u
X3 VDD Ibias Ibias VDD sg13_hv_pmos ad=0.68p pd=4.68u as=0.68p ps=4.68u w=2u l=0.4u
X4 a_118_854# a_n292_316# VSS.t1 VSS.t2 sg13_hv_nmos ad=0.408p pd=3.08u as=0.228p ps=1.58u w=1.2u l=1.5u
X5 out Ibias VDD VDD sg13_hv_pmos ad=0.68p pd=4.68u as=0.38p ps=2.38u w=2u l=0.4u
X6 VDD Ibias a_n38_854# VDD sg13_hv_pmos ad=0.38p pd=2.38u as=0.68p ps=4.68u w=2u l=0.4u
X7 VSS.t1 a_n292_316# a_n292_316# VSS.t0 sg13_hv_nmos ad=0.228p pd=1.58u as=0.408p ps=3.08u w=1.2u l=1.5u
R0 VSS.t2 VSS.n1 54.159
R1 VSS.n9 VSS.n0 17.0005
R2 VSS.n7 VSS.n0 17.0005
R3 VSS.t4 VSS.n10 17.0005
R4 VSS.t4 VSS.n8 17.0005
R5 VSS.n11 VSS.t4 17.0005
R6 VSS.n0 VSS.n1 0.00132504
R7 VSS.n0 VSS.t3 59.7206
R8 VSS.n2 VSS.n0 5.65307
R9 VSS.n16 VSS.n0 5.66717
R10 VSS.n0 VSS.n6 2.37908
R11 VSS.n0 VSS.n3 0.390232
R12 VSS.n0 VSS.n5 2.07352
R13 VSS.n0 VSS.n15 1.73604
R14 VSS.n3 VSS.t1 0.466392
R15 VSS.n0 VSS.n12 1.14955
R16 VSS.n13 VSS.n12 0.711964
R17 VSS.n3 VSS.n13 1.06462
R18 VSS.n15 VSS.n13 0.414606
R19 VSS.n15 VSS.n14 0.348136
R20 VSS.n12 VSS.n11 0.329475
R21 VSS.t1 VSS.n5 0.188185
R22 VSS.n14 VSS.n6 0.175605
R23 VSS.n6 VSS.n4 0.147116
R24 VSS.n14 VSS.n5 0.144407
R25 VSS.n16 VSS.n4 0.0318551
R26 VSS.n10 VSS.n9 0.028257
R27 VSS.n11 VSS.n7 0.028257
R28 VSS.n10 VSS.n2 0.0437469
R29 VSS.n9 VSS.n8 0.0190047
R30 VSS.n8 VSS.n7 0.0190047
R31 VSS VSS.n16 0.0159206
R32 VSS.n2 VSS.n4 0.0398086
R33 VSS.n1 VSS.t0 54.1613
C0 out VDD 0.54576f
C1 VDD a_n38_854# 0.68584f
C2 a_118_854# a_n292_316# 0.26102f
C3 + a_118_854# 0.16976f
C4 - VDD 0.50223f
C5 Ibias a_118_854# 0.13094f
C6 + a_n292_316# 0.01543f
C7 a_118_854# VDD 0.48163f
C8 VDD a_n292_316# 0.42654f
C9 + VDD 0.51871f
C10 Ibias VDD 2.296f
C11 out a_n38_854# 0.2119f
C12 - a_n38_854# 0.04649f
C13 out a_118_854# 0.3015f
C14 a_118_854# a_n38_854# 0.60011f
C15 out a_n292_316# 0.01536f
C16 out Ibias 0.29332f
C17 a_n38_854# a_n292_316# 0.37914f
C18 + a_n38_854# 0.09678f
C19 Ibias a_n38_854# 0.177f
C20 - a_n292_316# 0.18914f
C21 + - 0.10416f
C22 out VSS 1.43604f
C23 VDD VSS 1.65581f
C24 a_118_854# VSS 1.07912f
C25 a_n38_854# VSS 0.26791f
C26 VSS.t4 VSS 0.91484f
C27 VSS.t1 VSS 1.04668f
.ends
