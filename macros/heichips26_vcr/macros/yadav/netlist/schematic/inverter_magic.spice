** sch_path: /home/noah/Documents/freizeit/heichips/heichips26-voltage-controlled-resistor/macros/heichips26_vcr/macros/yadav/schematic/xschem/inverter.sch
.subckt inverter

.ends
