** sch_path: /home/santi/heichips26-voltage-controlled-resistor/macros/voltage_controlled_resistors/macros/vcr_bisection/testbenches/xschem/res_tb_linearity.sch
**.subckt res_tb_linearity
VDD VDD GND {VDD}
VS vsweep GND 1.5
Vmeas vd net1 0
.save i(vmeas)
E2 vd GND VOL=' {Vcm}+V(vsweep)/2 '
E3 vb GND VOL=' {Vcm}-V(vsweep)/2 '
vc vc_p GND 0
x1 vc_p net1 vb VDD GND vcr_bisection
**** begin user architecture code

.lib cornerMOSlv.lib mos_tt
.lib cornerMOShv.lib mos_tt
.lib cornerRES.lib res_typ
.lib cornerDIO.lib dio_tt
.lib cornerCAP.lib cap_typ

* .include ../../../netlist/pex/inverter_magic_pex_3.spice
.param VDD=3.3
.csparam VDD=VDD
.param Vcm=2.3
.csparam Vcm=Vcm
.param temp=27
.options savecurrents klu method=gear reltol=1e-3 abstol=1e-15 gmin=1e-15 rshunt=1e13
.control
let vcc = 1

save all
set appendwrite

repeat 5
  alter vc $&vcc

  * DC Sweep
  dc VS -1 1 1m
  remzerovec
  let vcc = vcc + 0.3
end
write res_tb_linearity.raw
set appendwrite

* Plotting
plot dc1.v(vsweep)/(dc1.i(vmeas)) dc2.v(vsweep)/(dc2.i(vmeas)) dc3.v(vsweep)/(dc3.i(vmeas)) dc4.v(vsweep)/(dc4.i(vmeas)) dc5.v(vsweep)/(dc5.i(vmeas)) ylimit 0 20k

plot dc1.i(vmeas) dc2.i(vmeas) dc3.i(vmeas) dc4.i(vmeas) dc5.i(vmeas)

* Write Data
unset appendwrite
set wr_vecnames
set wr_singlescale
wrdata ../plot_simulations/data/res_tb_linearity.txt v(vc_p) dc1.v(vsweep)/(dc1.i(Vmeas)) dc2.v(vsweep)/(dc2.i(Vmeas)) dc3.v(vsweep)/(dc3.i(Vmeas)) dc4.v(vsweep)/(dc4.i(Vmeas)) dc5.v(vsweep)/(dc5.i(Vmeas))

write res_tb_linearity.raw

*quit
.endc

**** end user architecture code
**.ends

* expanding   symbol:  vcr_bisection.sym # of pins=5
** sym_path: /home/santi/heichips26-voltage-controlled-resistor/macros/voltage_controlled_resistors/macros/vcr_bisection/schematic/xschem/vcr_bisection.sym
** sch_path: /home/santi/heichips26-voltage-controlled-resistor/macros/voltage_controlled_resistors/macros/vcr_bisection/schematic/xschem/vcr_bisection.sch
.subckt vcr_bisection Vctrl T1 T2 Vdd Vss
*.ipin T1
*.ipin T2
*.ipin Vctrl
*.ipin Vdd
*.ipin Vss
R1 net2 Vcm 10k
XM1 T1 net5 net7 Vcm sg13_hv_pmos w=50u l=10u ng=6 m=2 mm_ok=1
I0 Vdd net1 5u
x1 Vdd T1 Vss net2 net1 net2 opamp_rtr
I3 Vdd net3 5u
x2 Vdd T2 Vss net4 net3 net4 opamp_rtr
R2 Vcm net4 10k
x3 net6 Vss net5 Vctrl Vdd Vcm voltage_diff
I4 Vdd net6 5u
XM2 net7 net5 T2 Vcm sg13_hv_pmos w=50u l=10u ng=6 m=2 mm_ok=1
.ends

* expanding   symbol:  opamp_rtr.sym # of pins=6
** sym_path: /home/santi/heichips26-voltage-controlled-resistor/macros/voltage_controlled_resistors/macros/vcr_bisection/schematic/xschem/opamp_rtr.sym
** sch_path: /home/santi/heichips26-voltage-controlled-resistor/macros/voltage_controlled_resistors/macros/vcr_bisection/schematic/xschem/opamp_rtr.sch
.subckt opamp_rtr vdd inp vss inn ibias out
*.ipin inp
*.opin out
*.iopin vdd
*.ipin inn
*.ipin ibias
*.iopin vss
XXM6 out1_n inp ncmdiff_n vss sg13_hv_nmos w={w_diff_n} l={l_diff} ng={n_diff_n} m=1 mm_ok=1
XXM1 net1 inn ncmdiff_p vdd sg13_hv_pmos w={w_diff_p} l={l_diff} ng={n_diff_p} m=1 mm_ok=1
XXM2 ncmdiff_p inp out1_p vdd sg13_hv_pmos w={w_diff_p} l={l_diff} ng={n_diff_p} m=1 mm_ok=1
XXM3 ncmdiff_p vbias_p vdd vdd sg13_hv_pmos w={w_tail_p} l={l_bias} ng={n_tail_p} m=1 mm_ok=1
XXM4 vss net1 net1 vss sg13_hv_nmos w={w_load_n} l={l_load} ng={n_load_n} m=1 mm_ok=1
XXM5 out1_p net1 vss vss sg13_hv_nmos w={w_load_n} l={l_load} ng={n_load_n} m=1 mm_ok=1
XXM7 ncmdiff_n inn net2 vss sg13_hv_nmos w={w_diff_n} l={l_diff} ng={n_diff_n} m=1 mm_ok=1
XXM8 ncmdiff_n ibias vss vss sg13_hv_nmos w={w_tail_n} l={l_bias} ng={n_tail_n} m=1 mm_ok=1
XXM9 vdd net2 out1_n vdd sg13_hv_pmos w={w_load_p} l={l_load} ng={n_load_p} m=1 mm_ok=1
XXM10 net2 net2 vdd vdd sg13_hv_pmos w={w_load_p} l={l_load} ng={n_load_p} m=1 mm_ok=1
XXM25 nswa vref_p ncmdiff_p ncmdiff_p sg13_hv_pmos w={w_sw_p} l={l_sw} ng={n_sw_p} m=1 mm_ok=1
XXM26 nswa nswa vss vss sg13_hv_nmos w={w_gmn} l={l_bias} ng={n_gmn} m=1 mm_ok=1
XXM27 ncmdiff_n nswa vss vss sg13_hv_nmos w={w_gmn} l={l_bias} ng={n_gmn} m=1 mm_ok=1
XXM28 ncmdiff_n vref_n nswb vss sg13_hv_nmos w={w_sw_n} l={l_sw} ng={n_sw_n} m=1 mm_ok=1
XXM29 nswb nswb vdd vdd sg13_hv_pmos w={w_gmp} l={l_bias} ng={n_gmp} m=1 mm_ok=1
XXM30 ncmdiff_p nswb vdd vdd sg13_hv_pmos w={w_gmp} l={l_bias} ng={n_gmp} m=1 mm_ok=1
XXM13 out1_n nabn out1_p vss sg13_hv_nmos w={w_ab_n} l={l_ab} ng={n_ab_n} m=1 mm_ok=1
XXM14 out1_p nabp out1_n vdd sg13_hv_pmos w={w_ab_p} l={l_ab} ng={n_ab_p} m=1 mm_ok=1
XXM15 out1_n vbias_p vdd vdd sg13_hv_pmos w={w_ab_src} l={l_bias} ng={n_ab_src} m=1 mm_ok=1
XXM16 out1_p nab_ref vss vss sg13_hv_nmos w={w_ab_snk} l={l_bias} ng={n_ab_snk} m=1 mm_ok=1
XXM23 nab_ref vbias_p vdd vdd sg13_hv_pmos w={w_ab_src} l={l_bias} ng={n_ab_src} m=1 mm_ok=1
XXM24 nab_ref nab_ref vss vss sg13_hv_nmos w={w_ab_snk} l={l_bias} ng={n_ab_snk} m=1 mm_ok=1
XXM17 nabn vbias_p vdd vdd sg13_hv_pmos w={w_ab_src} l={l_bias} ng={n_ab_src} m=1 mm_ok=1
XXM18 nabn nabn net3 vss sg13_hv_nmos w={w_ab_n} l={l_ab} ng={n_ab_n} m=1 mm_ok=1
XXM19 net3 net3 vss vss sg13_hv_nmos w={w_ab_n} l={l_ab} ng={n_ab_n} m=1 mm_ok=1
XXM20 nabp nab_ref vss vss sg13_hv_nmos w={w_ab_snk} l={l_bias} ng={n_ab_snk} m=1 mm_ok=1
XXM21 nabp nabp net4 vdd sg13_hv_pmos w={w_ab_p} l={l_ab} ng={n_ab_p} m=1 mm_ok=1
XXM22 net4 net4 vdd vdd sg13_hv_pmos w={w_ab_p} l={l_ab} ng={n_ab_p} m=1 mm_ok=1
XXM11 out out1_n vdd vdd sg13_hv_pmos w={w_out_p} l={l_out} ng={n_out_p} m=1 mm_ok=1
XXM12 out out1_p vss vss sg13_hv_nmos w={w_out_n} l={l_out} ng={n_out_n} m=1 mm_ok=1
R1 out net5 {r_null}
C1 net5 out1_n {c_null}
R2 out net6 {r_null}
C2 net6 out1_p {c_null}
XXB1 ibias ibias vss vss sg13_hv_nmos w={w_bias_n} l={l_bias} ng={n_bias_n} m=1 mm_ok=1
XXB2 vbias_p ibias vss vss sg13_hv_nmos w={w_bias_n} l={l_bias} ng={n_bias_n} m=1 mm_ok=1
XXB5 vref_n vref_n vss vss sg13_hv_nmos w={w_ref_n} l={l_bias} ng={n_ref_n} m=1 mm_ok=1
XXB6 vref_p ibias vss vss sg13_hv_nmos w={w_bias_n} l={l_bias} ng={n_bias_n} m=1 mm_ok=1
XXB3 vbias_p vbias_p vdd vdd sg13_hv_pmos w={w_bias_p} l={l_bias} ng={n_bias_p} m=1 mm_ok=1
XXB4 vref_n vbias_p vdd vdd sg13_hv_pmos w={w_bias_p} l={l_bias} ng={n_bias_p} m=1 mm_ok=1
XXB7 vref_p vref_p vdd vdd sg13_hv_pmos w={w_ref_p} l={l_bias} ng={n_ref_p} m=1 mm_ok=1
**** begin user architecture code

*bias network
.param l_bias=2u
.param w_bias_p=10u
.param n_bias_p=4
.param w_bias_n=5u
.param n_bias_n=5
.param w_ref_n=5u
.param n_ref_n=4
.param w_ref_p=10u
.param n_ref_p=4
*first stage
.param l_diff=1u
.param l_load=4u

.param w_diff_n=5u
.param n_diff_n=4

.param w_diff_p=10u
.param n_diff_p=4

.param w_load_n=5u
.param n_load_n=4

.param w_load_p=10u
.param n_load_p=4

.param w_tail_n=5u
.param n_tail_n=4

.param w_tail_p=10u
.param n_tail_p=4

.param l_sw=1u
.param w_sw_p=10u
.param n_sw_p=4

.param w_sw_n=5u
.param n_sw_n=4

.param w_gmn=5u
.param n_gmn=4

.param w_gmp=10u
.param n_gmp=4

*output control circuit
.param w_ab_src=10u
.param n_ab_src=4
.param w_ab_snk=5u
.param n_ab_snk=4

.param w_ab_n=5u
.param n_ab_n=4
.param w_ab_p=10u
.param n_ab_p=4

.param l_ab=1u

.param w_out_p=20u
.param n_out_p=4
.param w_out_n=10u
.param n_out_n=4
.param l_out=0.5u

.param r_null=2k
.param c_null=200f

**** end user architecture code
.ends

* expanding   symbol:  voltage_diff.sym # of pins=6
** sym_path: /home/santi/heichips26-voltage-controlled-resistor/macros/voltage_controlled_resistors/macros/vcr_bisection/schematic/xschem/voltage_diff.sym
** sch_path: /home/santi/heichips26-voltage-controlled-resistor/macros/voltage_controlled_resistors/macros/vcr_bisection/schematic/xschem/voltage_diff.sch
.subckt voltage_diff ibias vss vout vin1 vdd vin2
*.iopin vin1
*.iopin vout
*.iopin vin2
*.iopin vss
*.iopin vdd
*.iopin ibias
XR5 net1 vin1 vss rhigh w=2e-6 l=100e-6 m=1 b=0 mm_ok=1
XR2 vout net1 vss rhigh w=2e-6 l=100e-6 m=1 b=0 mm_ok=1
XR3 net2 vin2 vss rhigh w=2e-6 l=100e-6 m=1 b=0 mm_ok=1
XR4 vss net2 vss rhigh w=2e-6 l=100e-6 m=1 b=0 mm_ok=1
x1 vdd net2 vss net1 ibias vout opamp_rtr
.ends

.GLOBAL GND
.GLOBAL VDD
.end
