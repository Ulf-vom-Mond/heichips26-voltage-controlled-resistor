* Extracted by KLayout with SG13CMOS5L LVS runset on : 18/09/2026 15:42

.SUBCKT vcr_bisection T1 T2 i1_b0 i1_b1 i1_b2 i1_b3 i1_b4 i2_b0 i2_b1 i2_b2
+ i2_b3 i2_b4 i3_b0 i3_b1 i3_b2 i3_b3 i3_b4 vctrl vdd vss
X$27 vss \$4 vdd \$4 T2 \$7 opamp_rtr
X$28 vss vdd \$7 i1_b2 i1_b1 i1_b0 i1_b3 i1_b4 isource_beta
X$31 vss vdd \$30 i3_b2 i3_b1 i3_b0 i3_b3 i3_b4 isource_beta
X$32 vss vdd \$16 i2_b2 i2_b1 i2_b0 i2_b3 i2_b4 isource_beta
X$33 vss \$28 vdd \$40 \$44 \$30 opamp_rtr
X$35 vss \$17 vdd \$17 T1 \$16 opamp_rtr
M$1 T1 T1 T1 vss sg13_hv_nmos L=2u W=15u AS=3.975p AD=3.975p PS=23.56u
+ PD=23.56u rfmode=0
M$2 T1 \$28 T2 vss sg13_hv_nmos L=10u W=15u AS=2.85p AD=2.85p PS=15.76u
+ PD=15.76u rfmode=0
R$24 vss \$28 vss rppd w=1u l=200u ps=0u b=0 m=1
R$44 \$54 vctrl vss rppd w=1u l=200u ps=0u b=0 m=1
R$45 vss vss vss rppd w=1u l=10u ps=0u b=0 m=2
R$50 \$54 \$17 vss rppd w=1u l=50u ps=0u b=0 m=1
R$56 \$4 \$54 vss rppd w=1u l=50u ps=0u b=0 m=1
.ENDS vcr_bisection

.SUBCKT isource_beta vss vdd out b2 b1 b0 b3 b4
M$1 \$2 \$2 \$2 vss sg13_hv_nmos L=0.5u W=100u AS=26.5p AD=26.5p PS=160.6u
+ PD=160.6u rfmode=0
M$2 \$2 \$5 \$22 vss sg13_hv_nmos L=4u W=120u AS=22.8p AD=22.8p PS=129.12u
+ PD=129.12u rfmode=0
M$35 vss vss vss vss sg13_hv_nmos L=0.5u W=20u AS=5.3p AD=5.3p PS=32.12u
+ PD=32.12u rfmode=0
M$36 vss \$5 \$5 vss sg13_hv_nmos L=4u W=40u AS=7.6p AD=7.6p PS=43.04u
+ PD=43.04u rfmode=0
M$57 vdd vdd vdd vdd sg13_hv_pmos L=0.4u W=18u AS=4.77p AD=4.77p PS=30.18u
+ PD=30.18u rfmode=0
M$58 vdd \$2 out vdd sg13_hv_pmos L=4u W=12u AS=2.28p AD=2.28p PS=13.52u
+ PD=13.52u rfmode=0
M$60 vdd \$2 \$5 vdd sg13_hv_pmos L=4u W=12u AS=2.28p AD=2.28p PS=13.52u
+ PD=13.52u rfmode=0
M$64 vdd \$2 \$2 vdd sg13_hv_pmos L=4u W=12u AS=2.28p AD=2.28p PS=13.52u
+ PD=13.52u rfmode=0
M$75 vss vss vss vss sg13_hv_nmos L=0.45u W=26u AS=6.89p AD=6.89p PS=41.12u
+ PD=41.12u rfmode=0
M$76 vss \$5 \$69 vss sg13_hv_nmos L=0.45u W=10u AS=1.9p AD=1.9p PS=10.76u
+ PD=10.76u rfmode=0
M$78 vss \$69 \$2 vss sg13_hv_nmos L=0.45u W=10u AS=1.9p AD=1.9p PS=10.76u
+ PD=10.76u rfmode=0
M$81 \$69 vdd vdd vdd sg13_hv_pmos L=10u W=1u AS=0.34p AD=0.34p PS=2.68u
+ PD=2.68u rfmode=0
M$83 vss b0 \$93 vss sg13_hv_nmos L=0.45u W=16u AS=3.04p AD=3.04p PS=16.76u
+ PD=16.76u rfmode=0
M$84 \$93 b1 \$95 vss sg13_hv_nmos L=0.45u W=16u AS=3.04p AD=3.04p PS=16.76u
+ PD=16.76u rfmode=0
M$85 \$95 b2 \$102 vss sg13_hv_nmos L=0.45u W=16u AS=3.04p AD=3.04p PS=16.76u
+ PD=16.76u rfmode=0
M$86 \$102 b3 \$98 vss sg13_hv_nmos L=0.45u W=16u AS=3.04p AD=3.04p PS=16.76u
+ PD=16.76u rfmode=0
M$87 \$98 b4 \$22 vss sg13_hv_nmos L=0.45u W=16u AS=3.04p AD=3.04p PS=16.76u
+ PD=16.76u rfmode=0
R$94 vss vss vss rppd w=1u l=10u ps=0u b=0 m=2
R$108 \$22 \$98 vss rppd w=1u l=160u ps=0u b=0 m=1
R$117 \$102 \$98 vss rppd w=1u l=80u ps=0u b=0 m=1
R$121 \$95 \$102 vss rppd w=1u l=40u ps=0u b=0 m=1
R$123 \$93 \$95 vss rppd w=1u l=20u ps=0u b=0 m=1
R$125 vss \$93 vss rppd w=1u l=10u ps=0u b=0 m=1
.ENDS isource_beta

.SUBCKT opamp_rtr vss out vdd inn inp ibias
M$1 \$36 \$36 \$36 vss sg13_hv_nmos L=1u W=5u AS=1.325p AD=1.325p PS=8.56u
+ PD=8.56u rfmode=0
M$2 \$36 \$29 \$10 vss sg13_hv_nmos L=1u W=5u AS=0.95p AD=0.95p PS=5.76u
+ PD=5.76u rfmode=0
M$5 vss vss vss vss sg13_hv_nmos L=0.45u W=22.5u AS=5.4p AD=5.4p PS=35.76u
+ PD=35.76u rfmode=0
M$6 vss ibias \$7 vss sg13_hv_nmos L=4u W=5u AS=0.95p AD=0.95p PS=5.76u
+ PD=5.76u rfmode=0
M$8 vss ibias ibias vss sg13_hv_nmos L=4u W=5u AS=0.95p AD=0.95p PS=5.76u
+ PD=5.76u rfmode=0
M$10 vss ibias \$87 vss sg13_hv_nmos L=4u W=5u AS=0.95p AD=0.95p PS=5.76u
+ PD=5.76u rfmode=0
M$13 vss \$33 \$35 vss sg13_hv_nmos L=4u W=5u AS=0.95p AD=0.95p PS=5.76u
+ PD=5.76u rfmode=0
M$15 vss \$33 \$33 vss sg13_hv_nmos L=4u W=5u AS=0.95p AD=0.95p PS=5.76u
+ PD=5.76u rfmode=0
M$17 vss \$33 \$36 vss sg13_hv_nmos L=4u W=5u AS=0.95p AD=0.95p PS=5.76u
+ PD=5.76u rfmode=0
M$20 vss \$138 \$138 vss sg13_hv_nmos L=1u W=5u AS=0.95p AD=0.95p PS=5.76u
+ PD=5.76u rfmode=0
M$21 \$138 \$29 \$29 vss sg13_hv_nmos L=1u W=5u AS=0.95p AD=0.95p PS=5.76u
+ PD=5.76u rfmode=0
M$26 vss \$36 out vss sg13_hv_nmos L=1u W=20u AS=3.8p AD=3.8p PS=23.04u
+ PD=23.04u rfmode=0
M$35 \$87 \$87 \$87 vss sg13_hv_nmos L=0.45u W=10u AS=2.65p AD=2.65p PS=18.18u
+ PD=18.18u rfmode=0
M$36 \$87 \$7 \$88 vss sg13_hv_nmos L=1u W=5u AS=0.95p AD=0.95p PS=5.76u
+ PD=5.76u rfmode=0
M$40 vss \$81 \$81 vss sg13_hv_nmos L=4u W=5u AS=0.95p AD=0.95p PS=6.52u
+ PD=6.52u rfmode=0
M$42 vss \$81 \$87 vss sg13_hv_nmos L=4u W=5u AS=0.95p AD=0.95p PS=6.52u
+ PD=6.52u rfmode=0
M$45 vss \$67 \$67 vss sg13_hv_nmos L=4u W=5u AS=0.95p AD=0.95p PS=6.52u
+ PD=6.52u rfmode=0
M$47 vss \$67 \$36 vss sg13_hv_nmos L=4u W=5u AS=0.95p AD=0.95p PS=6.52u
+ PD=6.52u rfmode=0
M$61 \$10 \$10 \$10 vdd sg13_hv_pmos L=1u W=15u AS=3.975p AD=3.975p PS=23.56u
+ PD=23.56u rfmode=0
M$62 \$10 \$35 \$36 vdd sg13_hv_pmos L=1u W=15u AS=2.85p AD=2.85p PS=15.76u
+ PD=15.76u rfmode=0
M$65 vdd vdd vdd vdd sg13_hv_pmos L=0.4u W=60u AS=14.775p AD=14.775p PS=87.88u
+ PD=87.88u rfmode=0
M$66 vdd \$76 \$76 vdd sg13_hv_pmos L=4u W=15u AS=2.85p AD=2.85p PS=16.52u
+ PD=16.52u rfmode=0
M$68 vdd \$76 \$10 vdd sg13_hv_pmos L=4u W=15u AS=2.85p AD=2.85p PS=16.52u
+ PD=16.52u rfmode=0
M$71 vdd \$88 \$88 vdd sg13_hv_pmos L=4u W=15u AS=2.85p AD=2.85p PS=16.52u
+ PD=16.52u rfmode=0
M$73 vdd \$88 \$34 vdd sg13_hv_pmos L=4u W=15u AS=2.85p AD=2.85p PS=16.52u
+ PD=16.52u rfmode=0
M$87 \$34 \$34 \$34 \$34 sg13_hv_pmos L=0.4u W=30u AS=7.95p AD=7.95p PS=48.18u
+ PD=48.18u rfmode=0
M$88 \$34 \$7 \$81 \$34 sg13_hv_pmos L=1u W=15u AS=2.85p AD=2.85p PS=15.76u
+ PD=15.76u rfmode=0
M$92 vdd \$7 \$29 vdd sg13_hv_pmos L=4u W=15u AS=2.85p AD=2.85p PS=15.76u
+ PD=15.76u rfmode=0
M$94 vdd \$7 \$7 vdd sg13_hv_pmos L=4u W=15u AS=2.85p AD=2.85p PS=15.76u
+ PD=15.76u rfmode=0
M$96 vdd \$7 \$10 vdd sg13_hv_pmos L=4u W=15u AS=2.85p AD=2.85p PS=15.76u
+ PD=15.76u rfmode=0
M$98 vdd \$7 \$33 vdd sg13_hv_pmos L=4u W=15u AS=2.85p AD=2.85p PS=15.76u
+ PD=15.76u rfmode=0
M$100 vdd \$7 \$34 vdd sg13_hv_pmos L=4u W=15u AS=2.85p AD=2.85p PS=15.76u
+ PD=15.76u rfmode=0
M$103 vdd \$3 \$3 vdd sg13_hv_pmos L=1u W=15u AS=2.85p AD=2.85p PS=15.76u
+ PD=15.76u rfmode=0
M$104 \$3 \$35 \$35 vdd sg13_hv_pmos L=1u W=15u AS=2.85p AD=2.85p PS=15.76u
+ PD=15.76u rfmode=0
M$109 vdd \$10 out vdd sg13_hv_pmos L=1u W=60u AS=11.4p AD=11.4p PS=63.04u
+ PD=63.04u rfmode=0
M$119 \$87 inn \$76 vss sg13_hv_nmos L=2u W=5u AS=0.95p AD=0.95p PS=6.52u
+ PD=6.52u rfmode=0
M$121 \$87 inp \$10 vss sg13_hv_nmos L=2u W=5u AS=0.95p AD=0.95p PS=6.52u
+ PD=6.52u rfmode=0
C$130 \$93 out cap_cmomf w=21u l=13.5u A=0p P=0u m=1
R$131 vss vss vss rhigh w=1u l=9u ps=0u b=0 m=2
C$133 \$64 out cap_cmomf w=13.5u l=21u A=0p P=0u m=1
R$136 \$93 \$10 vss rhigh w=1u l=36u ps=0u b=0 m=1
R$140 \$36 \$64 vss rhigh w=1u l=36u ps=0u b=0 m=1
M$143 \$34 inn \$67 \$34 sg13_hv_pmos L=2u W=15u AS=2.85p AD=2.85p PS=16.52u
+ PD=16.52u rfmode=0
M$145 \$34 inp \$36 \$34 sg13_hv_pmos L=2u W=15u AS=2.85p AD=2.85p PS=16.52u
+ PD=16.52u rfmode=0
.ENDS opamp_rtr
