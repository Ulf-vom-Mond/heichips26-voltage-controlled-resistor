** sch_path: /home/raiku/vcr/macros/heichips26_analog_project/macros/yadav/schematic/xschem/yadavVCR.sch
.subckt yadavVCR

.ends
