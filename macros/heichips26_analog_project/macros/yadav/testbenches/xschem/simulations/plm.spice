** sch_path: /home/raiku/plm/heichips26-voltage-controlled-resistor/macros/heichips26_analog_project/macros/yadav/testbenches/xschem/plm.sch
**.subckt plm
Vres net1 net5 0
.save i(vres)
vress net1 GND 0
vcons net2 GND 0
vdds net3 GND 3.3
Vcon net2 net4 0
.save i(vcon)
Vdd net3 net7 0
.save i(vdd)
vress1 net8 GND 1.25
x1 net7 net5 net6 net4 GND yadav
Vres6 net6 net8 0
.save i(vres6)
**** begin user architecture code

* .include ../../../netlist/pex/inverter_magic_pex_3.spice
.param temp=27
.options savecurrents klu method=gear reltol=1e-3 abstol=1e-15 gmin=1e-15 rshunt=1e10
.control
save all
set appendwrite

* DC Sweep
* dc vcon 1 1.5 1m
* remzerovec

* plot v(vres)/i(Vres)
*plot v(VStage1)
*plot v(VStage2)

let vcc = 0.4
repeat 5
  alter vcons $&vcc

  * DC Sweep
  dc vress 0.3 3.3 1m
  remzerovec
  let vcc = vcc + 0.15
end
set appendwrite

*plot dc1.v(V1)/(dc1.i(Vres)) dc2.v(V1)/(dc2.i(Vres)) dc3.v(V1)/(dc3.i(Vres)) dc4.v(V1)/(dc4.i(Vres)) dc5.v(V1)/(dc5.i(Vres))

*plot dc1.v(V1)/(dc1.i(Vres6)) dc2.v(V1)/(dc2.i(Vres6)) dc3.v(V1)/(dc3.i(Vres6)) dc4.v(V1)/(dc4.i(Vres6)) dc5.v(V1)/(dc5.i(Vres6))

plot (dc1.i(Vres)) (dc2.i(Vres)) (dc3.i(Vres)) (dc4.i(Vres)) (dc5.i(Vres))

plot (dc1.i(Vres6)) (dc2.i(Vres6)) (dc3.i(Vres6)) (dc4.i(Vres6))  (dc5.i(Vres6))

* Write Data
unset appendwrite
set wr_vecnames
set wr_singlescale

*quit
.endc

.lib cornerMOSlv.lib mos_tt
.lib cornerMOShv.lib mos_tt
.lib cornerRES.lib res_typ
.lib cornerDIO.lib dio_tt

**** end user architecture code
**.ends

* expanding   symbol:  yadav.sym # of pins=5
** sym_path: /home/raiku/plm/heichips26-voltage-controlled-resistor/macros/heichips26_analog_project/macros/yadav/schematic/xschem/yadav.sym
** sch_path: /home/raiku/plm/heichips26-voltage-controlled-resistor/macros/heichips26_analog_project/macros/yadav/schematic/xschem/yadav.sch
.subckt yadav Vdd Rin Rout Vc Vss
*.ipin Vc
*.iopin Vss
*.iopin Vdd
*.ipin Rin
*.opin Rout
XM3 Vdd Rin net2 Vss sg13_hv_nmos w=0.72u l=4.14u ng=2 m=1 mm_ok=1
XM13 net1 net1 Vdd Vdd sg13_hv_pmos w=18.5u l=2.16u ng=2 m=1 mm_ok=1
XM1 net4 Rin net3 Vss sg13_hv_nmos w=0.72u l=4.14u ng=2 m=1 mm_ok=1
XM5 net1 net2 net3 Vss sg13_hv_nmos w=0.72u l=4.14u ng=2 m=1 mm_ok=1
XM2 net1 Rout net3 Vss sg13_hv_nmos w=0.72u l=4.14u ng=2 m=1 mm_ok=1
XM16 net4 net4 Vdd Vdd sg13_hv_pmos w=18.5u l=2.16u ng=2 m=1 mm_ok=1
XM7 net2 Vc Vss Vss sg13_hv_nmos w=0.72u l=4.14u ng=2 m=1 mm_ok=1
XM6 net4 net7 net3 Vss sg13_hv_nmos w=0.72u l=4.14u ng=2 m=1 mm_ok=1
XM14 net5 net1 Vdd Vdd sg13_hv_pmos w=18.5u l=2.16u ng=2 m=1 mm_ok=1
XM8 net7 Vc Vss Vss sg13_hv_nmos w=0.72u l=4.14u ng=2 m=1 mm_ok=1
XM4 Vdd Rout net7 Vss sg13_hv_nmos w=0.72u l=4.14u ng=2 m=1 mm_ok=1
XM9 net5 net5 Vss Vss sg13_hv_nmos w=0.72u l=2.16u ng=2 m=1 mm_ok=1
XM10 Rout net5 Vss Vss sg13_hv_nmos w=0.72u l=2.16u ng=2 m=1 mm_ok=1
XM17 Rout net4 Vdd Vdd sg13_hv_pmos w=18.5u l=2.16u ng=2 m=1 mm_ok=1
XM18 net6 net4 Vdd Vdd sg13_hv_pmos w=18.5u l=2.16u ng=2 m=1 mm_ok=1
XM11 net6 net6 Vss Vss sg13_hv_nmos w=0.72u l=2.16u ng=2 m=1 mm_ok=1
XM12 Rin net6 Vss Vss sg13_hv_nmos w=0.72u l=2.16u ng=2 m=1 mm_ok=1
XM15 Rin net1 Vdd Vdd sg13_hv_pmos w=18.5u l=2.16u ng=2 m=1 mm_ok=1
I0 net3 Vss 60u
.ends

.GLOBAL GND
.end
