** sch_path: /home/raiku/vcr/macros/heichips26_analog_project/macros/yadav/testbenches/xschem/plm.sch
**.subckt plm
Vres net5 net2 0
.save i(vres)
vdds net1 GND 3.3
Vdd net1 net7 0
.save i(vdd)
Vres6 net3 net4 0
.save i(vres6)
E1 net5 GND VOL=' {Vcm} + v(Vdif)/2 '
E2 net4 GND VOL=' {Vcm} - v(Vdif)/2 '
Vdifs Vdif GND 0
x1 net7 net2 net3 net8 GND YadavVCR
vcons net6 GND 0
Vcon net6 net8 0
.save i(vcon)
**** begin user architecture code

* .include ../../../netlist/pex/inverter_magic_pex_3.spice
.param temp=27
.options savecurrents klu method=gear reltol=1e-3 abstol=1e-15 gmin=1e-15 rshunt=1e10
.control
.param Vcm=1.25
.csparam Vcm=Vcm
save all
set appendwrite

* DC Sweep
* dc vcon 1 1.5 1m
* remzerovec

* plot v(vres)/i(Vres)
*plot v(VStage1)
*plot v(VStage2)

let vcc = 0.1
let Vcm = 1.65

repeat 5
  alter vcons $&vcc

  * DC Sweep
  dc Vdifs -1.6 1.6 1m
  remzerovec
  let vcc = vcc + 0.5
end
set appendwrite

*plot dc1.v(V1)/(dc1.i(Vres)) dc2.v(V1)/(dc2.i(Vres)) dc3.v(V1)/(dc3.i(Vres)) dc4.v(V1)/(dc4.i(Vres)) dc5.v(V1)/(dc5.i(Vres))

*plot dc1.v(V1)/(dc1.i(Vres6)) dc2.v(V1)/(dc2.i(Vres6)) dc3.v(V1)/(dc3.i(Vres6)) dc4.v(V1)/(dc4.i(Vres6)) dc5.v(V1)/(dc5.i(Vres6))

plot (dc1.i(Vres)) (dc2.i(Vres)) (dc3.i(Vres)) (dc4.i(Vres)) (dc5.i(Vres))

plot (dc1.i(Vres6)) (dc2.i(Vres6)) (dc3.i(Vres6)) (dc4.i(Vres6))  (dc5.i(Vres6))

* Write Data
unset appendwrite
set wr_vecnames
set wr_singlescale

*quit
.endc

.lib cornerMOSlv.lib mos_tt
.lib cornerMOShv.lib mos_tt
.lib cornerRES.lib res_typ
.lib cornerDIO.lib dio_tt

**** end user architecture code
**.ends

* expanding   symbol:  YadavVCR.sym # of pins=5
** sym_path: /home/raiku/vcr/macros/heichips26_analog_project/macros/yadav/schematic/xschem/YadavVCR.sym
** sch_path: /home/raiku/vcr/macros/heichips26_analog_project/macros/yadav/schematic/xschem/YadavVCR.sch
.subckt YadavVCR Vdd Rin Rout Vc Vss
*.ipin Vc
*.iopin Vss
*.iopin Vdd
*.ipin Rin
*.opin Rout
XM3 Vdd Rin net2 Vss sg13_hv_nmos w=0.72u l=4.14u ng=2 m=1 mm_ok=1
XM13 net1 net1 Vdd Vdd sg13_hv_pmos w=18.5u l=2.16u ng=2 m=1 mm_ok=1
XM1 net3 Rin Vss Vss sg13_hv_nmos w=0.72u l=4.14u ng=2 m=1 mm_ok=1
XM5 net1 net2 Vss Vss sg13_hv_nmos w=0.72u l=4.14u ng=2 m=1 mm_ok=1
XM2 net1 Rout Vss Vss sg13_hv_nmos w=0.72u l=4.14u ng=2 m=1 mm_ok=1
XM16 net3 net3 Vdd Vdd sg13_hv_pmos w=18.5u l=2.16u ng=2 m=1 mm_ok=1
XM7 net2 Vc Vss Vss sg13_hv_nmos w=0.72u l=4.14u ng=2 m=1 mm_ok=1
XM6 net3 net6 Vss Vss sg13_hv_nmos w=0.72u l=4.14u ng=2 m=1 mm_ok=1
XM14 net4 net1 Vdd Vdd sg13_hv_pmos w=18.5u l=2.16u ng=2 m=1 mm_ok=1
XM8 net6 Vc Vss Vss sg13_hv_nmos w=0.72u l=4.14u ng=2 m=1 mm_ok=1
XM4 Vdd Rout net6 Vss sg13_hv_nmos w=0.72u l=4.14u ng=2 m=1 mm_ok=1
XM9 net4 net4 Vss Vss sg13_hv_nmos w=0.72u l=2.16u ng=2 m=1 mm_ok=1
XM10 Rin net4 Vss Vss sg13_hv_nmos w=0.72u l=2.16u ng=2 m=1 mm_ok=1
XM17 Rin net3 Vdd Vdd sg13_hv_pmos w=18.5u l=2.16u ng=2 m=1 mm_ok=1
XM18 net5 net3 Vdd Vdd sg13_hv_pmos w=18.5u l=2.16u ng=2 m=1 mm_ok=1
XM11 net5 net5 Vss Vss sg13_hv_nmos w=0.72u l=2.16u ng=2 m=1 mm_ok=1
XM12 Rout net5 Vss Vss sg13_hv_nmos w=0.72u l=2.16u ng=2 m=1 mm_ok=1
XM15 Rout net1 Vdd Vdd sg13_hv_pmos w=18.5u l=2.16u ng=2 m=1 mm_ok=1
.ends

.GLOBAL GND
.end
