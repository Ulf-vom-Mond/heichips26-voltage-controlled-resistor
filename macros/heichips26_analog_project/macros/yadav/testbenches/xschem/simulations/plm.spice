** sch_path: /home/raiku/plm/heichips26-voltage-controlled-resistor/macros/heichips26_analog_project/macros/yadav/testbenches/xschem/plm.sch
**.subckt plm
Vres net1 V1 0
.save i(vres)
vress net1 GND 0
vcons net2 GND 0
vdds net3 GND 3.3
Vcon net2 Vc 0
.save i(vcon)
Vdd net3 P 0
.save i(vdd)
XM3 P V1 K1 GND sg13_hv_nmos w=0.72u l=4.14u ng=2 m=1 mm_ok=1
XM13 net4 net4 P P sg13_hv_pmos w=18.5u l=2.16u ng=2 m=1 mm_ok=1
XM1 K3 V1 net16 GND sg13_hv_nmos w=0.72u l=4.14u ng=2 m=1 mm_ok=1
XM5 net14 K1 K2 GND sg13_hv_nmos w=0.72u l=4.14u ng=2 m=1 mm_ok=1
XM2 net13 K1207 net15 GND sg13_hv_nmos w=0.72u l=4.14u ng=2 m=1 mm_ok=1
XM16 K3 K3 P P sg13_hv_pmos w=18.5u l=2.16u ng=2 m=1 mm_ok=1
XM7 net7 Vc GND GND sg13_hv_nmos w=0.72u l=4.14u ng=2 m=1 mm_ok=1
XM6 K3 net10 K2 GND sg13_hv_nmos w=0.72u l=4.14u ng=2 m=1 mm_ok=1
XM14 K4 net4 P P sg13_hv_pmos w=18.5u l=2.16u ng=2 m=1 mm_ok=1
XM8 net17 Vc GND GND sg13_hv_nmos w=0.72u l=4.14u ng=2 m=1 mm_ok=1
XM4 P K1207 net10 GND sg13_hv_nmos w=0.72u l=4.14u ng=2 m=1 mm_ok=1
XM9 net5 net5 GND GND sg13_hv_nmos w=0.72u l=2.16u ng=2 m=1 mm_ok=1
XM10 net12 net5 GND GND sg13_hv_nmos w=0.72u l=2.16u ng=2 m=1 mm_ok=1
XM17 K1207 K3 P P sg13_hv_pmos w=18.5u l=2.16u ng=2 m=1 mm_ok=1
XM18 net11 K3 P P sg13_hv_pmos w=18.5u l=2.16u ng=2 m=1 mm_ok=1
XM11 K1203 K1203 GND GND sg13_hv_nmos w=0.72u l=2.16u ng=2 m=1 mm_ok=1
XM12 K121 K1203 GND GND sg13_hv_nmos w=0.72u l=2.16u ng=2 m=1 mm_ok=1
XM15 net8 net4 P P sg13_hv_pmos w=18.5u l=2.16u ng=2 m=1 mm_ok=1
I0 K2 net6 70u
Vres1 net6 GND 0
.save i(vres1)
Vres2 K1 net7 0
.save i(vres2)
Vres3 net9 K121 0
.save i(vres3)
Vres4 net9 V1 0
.save i(vres4)
Vres5 net8 net9 0
.save i(vres5)
Vres7 net11 K1203 0
.save i(vres7)
Vres8 K1207 net12 0
.save i(vres8)
Vres9 K4 net5 0
.save i(vres9)
Vres10 net4 K5 0
.save i(vres10)
Vres11 K5 net14 0
.save i(vres11)
Vres12 K5 net13 0
.save i(vres12)
Vres13 net16 K2 0
.save i(vres13)
Vres14 net15 K2 0
.save i(vres14)
Vres15 net10 net17 0
.save i(vres15)
Vres6 K1207 net18 0
.save i(vres6)
vress1 net18 GND 1.25
**** begin user architecture code

* .include ../../../netlist/pex/inverter_magic_pex_3.spice
.param temp=27
.options savecurrents klu method=gear reltol=1e-3 abstol=1e-15 gmin=1e-15 rshunt=1e10
.control
save all
set appendwrite

* DC Sweep
* dc vcon 1 1.5 1m
* remzerovec

* plot v(vres)/i(Vres)
*plot v(VStage1)
*plot v(VStage2)

let vcc = 0.4
repeat 5
  alter vcons $&vcc

  * DC Sweep
  dc vress 0.5 2.6 1m
  remzerovec
  let vcc = vcc + 0.15
end
set appendwrite

*plot dc1.v(V1)/(dc1.i(Vres)) dc2.v(V1)/(dc2.i(Vres)) dc3.v(V1)/(dc3.i(Vres)) dc4.v(V1)/(dc4.i(Vres)) dc5.v(V1)/(dc5.i(Vres))

*plot dc1.v(V1)/(dc1.i(Vres6)) dc2.v(V1)/(dc2.i(Vres6)) dc3.v(V1)/(dc3.i(Vres6)) dc4.v(V1)/(dc4.i(Vres6)) dc5.v(V1)/(dc5.i(Vres6))

plot (dc1.i(Vres)) (dc2.i(Vres)) (dc3.i(Vres)) (dc4.i(Vres)) (dc5.i(Vres))

plot (dc1.i(Vres6)) (dc2.i(Vres6)) (dc3.i(Vres6)) (dc4.i(Vres6))  (dc5.i(Vres6))

* Write Data
unset appendwrite
set wr_vecnames
set wr_singlescale

*quit
.endc

.lib cornerMOSlv.lib mos_tt
.lib cornerMOShv.lib mos_tt
.lib cornerRES.lib res_typ
.lib cornerDIO.lib dio_tt

**** end user architecture code
**.ends
.GLOBAL GND
.end
